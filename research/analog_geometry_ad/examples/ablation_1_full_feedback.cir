Fast AD centered state behavioral P5
.options reltol=1e-7 abstol=1e-12 vntol=1e-9
.model SW SW(Ron=230.0 Roff=1e12 Vt=0.5 Vh=0.1)
Vreset reset 0 PULSE(1 0 10u 10n 10n 25000.0u 50000.0u)
Vsample sample 0 PULSE(0 1 350u 10n 10n 400u 1200u)
Vupdate update 0 PULSE(0 1 770u 10n 10n 400u 1200u)
Sreset state 0 reset 0 SW
Cstate state 0 9.9999999999999995e-08 IC=0
Rleak state 0 1e12
Ileak state 0 -7.600000000003324e-11
Cnext stored 0 9.9999999999999995e-08 IC=0
Rnext stored 0 1e12
Ssample candidate stored sample 0 SW
Supdate stored_read state update 0 SW
Bstored stored_read 0 V=(v(stored)-(-4.9641614238704612e-06))/(0.99999963197701602)
Icharge 0 state PULSE(0 -4.9999999999999996e-05 1170.02u 1n 1n 9n 1200u)
Ithermal0 0 state PULSE(0 2.5220811226736537e-06 1170.02u 1n 1n 9n 48000u)
Ithermal1 0 state PULSE(0 3.8976293413115457e-06 2370.02u 1n 1n 9n 48000u)
Ithermal2 0 state PULSE(0 4.3360928227507968e-06 3570.02u 1n 1n 9n 48000u)
Ithermal3 0 state PULSE(0 -4.1203049342121758e-07 4770.0200000000004u 1n 1n 9n 48000u)
Ithermal4 0 state PULSE(0 3.086834141141695e-06 5970.0200000000004u 1n 1n 9n 48000u)
Ithermal5 0 state PULSE(0 2.8508339278417943e-06 7170.0200000000004u 1n 1n 9n 48000u)
Ithermal6 0 state PULSE(0 -4.5897549289437197e-06 8370.0200000000004u 1n 1n 9n 48000u)
Ithermal7 0 state PULSE(0 -3.0475548116298571e-07 9570.0200000000004u 1n 1n 9n 48000u)
Ithermal8 0 state PULSE(0 1.4133307986966545e-06 10770.02u 1n 1n 9n 48000u)
Ithermal9 0 state PULSE(0 -3.4585592740812496e-06 11970.02u 1n 1n 9n 48000u)
Ithermal10 0 state PULSE(0 -1.8739427886198026e-06 13170.02u 1n 1n 9n 48000u)
Ithermal11 0 state PULSE(0 -3.1889828369295957e-06 14370.02u 1n 1n 9n 48000u)
Ithermal12 0 state PULSE(0 1.2499677906820969e-06 15570.02u 1n 1n 9n 48000u)
Ithermal13 0 state PULSE(0 -1.6055073115412836e-07 16770.02u 1n 1n 9n 48000u)
Ithermal14 0 state PULSE(0 -2.9360217263770687e-06 17970.02u 1n 1n 9n 48000u)
Ithermal15 0 state PULSE(0 5.6710576798558117e-06 19170.02u 1n 1n 9n 48000u)
Ithermal16 0 state PULSE(0 -1.5697724285945724e-06 20370.02u 1n 1n 9n 48000u)
Ithermal17 0 state PULSE(0 -2.9424226564877178e-06 21570.02u 1n 1n 9n 48000u)
Ithermal18 0 state PULSE(0 1.482399309436281e-06 22770.02u 1n 1n 9n 48000u)
Ithermal19 0 state PULSE(0 4.7078185659736436e-06 23970.02u 1n 1n 9n 48000u)
Vreadnoise readnoise 0 PWL(0 5.6694197130179119e-07 1.0000000000000001e-05 -3.9954390413242734e-06 2.0000000000000002e-05 -3.1450238540396342e-06 3.0000000000000004e-05 6.3572208547540105e-06 4.0000000000000003e-05 1.0362205346227051e-05 5.0000000000000002e-05 -2.7046284549245979e-06 6.0000000000000008e-05 1.68963382308095e-06 7.0000000000000007e-05 1.1921633262500281e-05 8.0000000000000007e-05 6.8956424272017331e-06 9.0000000000000006e-05 -2.2924957738457881e-06 0.0001 -2.5159604592855064e-06 0.00011 1.3815465000113404e-06 0.00012000000000000002 7.1785116812926341e-07 0.00013000000000000002 -2.8184194369591307e-06 0.00014000000000000001 9.1568303927467962e-07 0.00015000000000000001 3.6134292644269135e-07 0.00016000000000000001 1.0362533882366445e-06 0.00017000000000000001 -6.745075714194371e-06 0.00018000000000000001 -2.0587769775494761e-06 0.00019000000000000001 -5.8292180427748007e-08 0.00020000000000000001 2.7297218588955249e-06 0.00021000000000000001 -1.2313060120968321e-06 0.00022000000000000001 -3.3343259881133955e-06 0.00023000000000000001 -7.5876596966112458e-06 0.00024000000000000003 -2.2278063140688163e-06 0.00025000000000000001 -3.3918878470577765e-07 0.00026000000000000003 -5.5426800437601255e-07 0.00027 3.262604474729024e-07 0.00028000000000000003 -6.1351763307751743e-07 0.00029 1.4565862767847131e-06 0.00030000000000000003 -1.0699704491593307e-06 0.00031 -4.3309046046148668e-06 0.00032000000000000003 3.7986644724871338e-06 0.00033000000000000005 2.398511710564372e-06 0.00034000000000000002 -1.8391463858613007e-06 0.00035000000000000005 -3.2625193791067039e-06 0.00036000000000000002 -1.5433146000237088e-06 0.00037000000000000005 -8.9877986164417681e-06 0.00038000000000000002 6.2983240834867387e-06 0.00039000000000000005 1.5132450263870297e-06 0.00040000000000000002 -6.5571247972891069e-07 0.00041000000000000005 2.6891932531893305e-06 0.00042000000000000002 -1.2810527277032655e-06 0.00043000000000000004 -4.0313550771212033e-06 0.00044000000000000002 -9.3561854839647996e-06 0.00045000000000000004 -6.6789787760315291e-06 0.00046000000000000001 5.3139784454224356e-06 0.00047000000000000004 -4.4111615371294469e-06 0.00048000000000000007 -9.6655529056527075e-06 0.00049000000000000009 1.3298301659821046e-06 0.00050000000000000001 -3.4870354410354703e-06 0.00051000000000000004 -1.4142568828546605e-06 0.00052000000000000006 1.0985173771105686e-07 0.00053000000000000009 -2.2586697806913594e-06 0.00054000000000000001 4.3044971899304681e-06 0.00055000000000000003 -1.866624887847625e-07 0.00056000000000000006 -3.4181548295625214e-06 0.00057000000000000009 8.182335046373809e-06 0.00058 3.491003488040437e-06 0.00059000000000000003 6.5583702954769828e-07 0.00060000000000000006 1.1575012814768603e-07 0.00061000000000000008 -3.0246955422166924e-06 0.00062 2.5765842358874988e-06 0.00063000000000000003 -6.2961308386225804e-07 0.00064000000000000005 3.7817501618749248e-06 0.00065000000000000008 -3.2812869151996761e-06 0.0006600000000000001 1.4019471352283e-06 0.00067000000000000002 2.7126828512748394e-06 0.00068000000000000005 -4.8094341056253697e-07 0.00069000000000000008 -3.1948316693964863e-06 0.0007000000000000001 4.0197562235089018e-06 0.00071000000000000002 1.3425862322509808e-06 0.00072000000000000005 -1.2063583803864531e-05 0.00073000000000000007 -6.070342526213548e-07 0.0007400000000000001 3.370752481367018e-06 0.00075000000000000002 3.435289627493792e-06 0.00076000000000000004 -9.7615574843421473e-06 0.00077000000000000007 3.5287685302817295e-06 0.00078000000000000009 1.8055268431497886e-06 0.00079000000000000001 -1.0841287538997918e-05 0.00080000000000000004 7.2727518826258851e-06 0.00081000000000000006 7.0710851544804014e-07 0.00082000000000000009 -8.9348609001087966e-07 0.00083000000000000012 -2.0859628469487367e-06 0.00084000000000000003 -1.014155011174786e-06 0.00085000000000000006 -4.7967012592569148e-07 0.00086000000000000009 4.6415047669574285e-06 0.00087000000000000011 1.0980740605655309e-06 0.00088000000000000003 -6.0487608441233403e-07 0.00089000000000000006 1.3127205333545049e-06 0.00090000000000000008 4.7444129292165724e-06 0.00091000000000000011 6.9202047821747031e-06 0.00092000000000000003 -2.571026141622467e-06 0.00093000000000000005 -3.3113541635911566e-06 0.00094000000000000008 3.810014850472553e-07 0.00095000000000000011 -8.7793580032114402e-07 0.00096000000000000013 1.1164310092775747e-07 0.00097000000000000005 4.3440661923131157e-06 0.00098000000000000019 7.3819765391043285e-06 0.00098999999999999999 1.9354466157083092e-06 0.001 -1.0398083084869962e-05 0.00101 2.524688614668349e-06 0.0010200000000000001 6.5441660483589942e-06 0.0010300000000000001 -6.1413479879044767e-06 0.0010400000000000001 -6.1018850272277222e-06 0.0010500000000000002 -3.4597264079623288e-06 0.0010600000000000002 -6.4374823376384024e-06 0.00107 -3.4659440651366893e-06 0.00108 -1.3828413804831953e-06 0.00109 5.4573133699861055e-06 0.0011000000000000001 -5.7190992839202954e-06 0.0011100000000000001 -1.4772406095914207e-06 0.0011200000000000001 -7.4015294612702571e-06 0.0011300000000000001 5.810259882405933e-06 0.0011400000000000002 -3.8938397719427496e-06 0.0011500000000000002 2.2542437960682205e-06 0.00116 -3.7229488418402558e-06 0.00117 6.1486332826043827e-07 0.0011800000000000001 -3.4994187320867244e-06 0.0011900000000000001 9.1776668777916889e-06 0.0012000000000000001 3.196171540312133e-06 0.0012100000000000001 -4.5687028479327449e-06 0.0012200000000000002 7.2117526445475482e-06 0.0012300000000000002 -2.8287727018279077e-06 0.00124 2.1737763245129555e-06 0.00125 -7.8897232294763208e-06 0.0012600000000000001 -1.9068745968583867e-06 0.0012700000000000001 -5.184533684479368e-06 0.0012800000000000001 2.2850097151629525e-06 0.0012900000000000001 -1.1894568092531503e-06 0.0013000000000000002 1.0420281179039777e-05 0.0013100000000000002 -7.0470828816570976e-06 0.0013200000000000002 1.116867939912571e-06 0.00133 2.3371087583741055e-06 0.00134 4.1179996415868564e-07 0.0013500000000000001 -5.7521872779122859e-06 0.0013600000000000001 4.0279890299421439e-06 0.0013700000000000001 -6.4881264125596087e-06 0.0013800000000000002 5.3009910910240622e-06 0.0013900000000000002 3.1536237706417001e-06 0.0014000000000000002 -3.3131536871348562e-06 0.00141 7.4664379305849825e-06 0.00142 -4.1026965236925908e-06 0.0014300000000000001 5.0717756468712084e-06 0.0014400000000000001 -6.2310938625108849e-06 0.0014500000000000001 9.5292738070053633e-06 0.0014600000000000001 -1.8536677227302779e-06 0.0014700000000000002 -3.5946321383134629e-06 0.0014800000000000002 -1.1490720980699328e-05 0.0014900000000000002 1.8206007021449388e-06 0.0015 5.3438651074690169e-06 0.0015100000000000001 -4.1947627297944659e-06 0.0015200000000000001 -3.2802530991433033e-07 0.0015300000000000001 2.3036710853556798e-06 0.0015400000000000001 7.1015831964158503e-06 0.0015500000000000002 -7.021726540508624e-06 0.0015600000000000002 -9.7038630135591925e-06 0.0015700000000000002 1.6858539958394818e-06 0.00158 1.8902755078498533e-06 0.0015900000000000001 -3.8660225099692278e-07 0.0016000000000000001 2.8279047302983623e-06 0.0016100000000000001 1.5335509406617904e-06 0.0016200000000000001 -8.1402146671666651e-06 0.0016300000000000002 -1.1187668823761905e-06 0.0016400000000000002 -1.6752953736235231e-06 0.0016500000000000002 -3.6705533573988103e-08 0.0016600000000000002 -2.4339135868031368e-06 0.00167 2.4897427745542082e-06 0.0016800000000000001 1.2529557375965227e-06 0.0016900000000000001 -4.1776591944970913e-06 0.0017000000000000001 1.0126964033170396e-05 0.0017100000000000001 9.8155518076586925e-06 0.0017200000000000002 1.2068762943042517e-06 0.0017300000000000002 -1.2330072531973438e-09 0.0017400000000000002 3.4827473985286882e-06 0.00175 6.3731761903253833e-07 0.0017600000000000001 -9.0079503664333043e-07 0.0017700000000000001 1.5190139713933805e-06 0.0017800000000000001 -7.3830518019921302e-06 0.0017900000000000001 -7.5215394006016599e-06 0.0018000000000000002 -4.8561824284912143e-06 0.0018100000000000002 2.6622274150553177e-06 0.0018200000000000002 3.3572118426886168e-06 0.0018300000000000002 7.1809362403223158e-06 0.0018400000000000001 -1.7661003085920819e-07 0.0018500000000000001 3.7070112709437267e-06 0.0018600000000000001 -2.4711373579388948e-06 0.0018700000000000001 -2.7090795418912767e-06 0.0018800000000000002 6.714105013242083e-06 0.0018900000000000002 -9.1265746871651792e-06 0.0019000000000000002 5.9143053850019518e-07 0.0019100000000000002 -2.8006766578830976e-06 0.0019200000000000003 4.0177730601165102e-06 0.0019300000000000001 -7.5914133746517206e-07 0.0019400000000000001 -4.2844933170036088e-06 0.0019500000000000001 -3.9656068079941757e-06 0.0019600000000000004 -1.0273156891203754e-06 0.00197 -4.9029578087262559e-06 0.00198 2.093928596511125e-06 0.00199 7.6982242677943861e-07 0.002 3.1555521690469641e-06 0.0020100000000000001 9.845491731505091e-07 0.0020200000000000001 -2.3508876026850357e-06 0.0020300000000000001 -1.8844747491532873e-07 0.0020400000000000001 -1.4791318972135996e-06 0.0020500000000000002 -3.5656560852360213e-06 0.0020600000000000002 7.536228691938451e-07 0.0020700000000000002 4.4076807510591037e-06 0.0020800000000000003 1.2651982993989892e-06 0.0020900000000000003 -1.3206501873343503e-07 0.0021000000000000003 8.2698354348003492e-06 0.0021100000000000003 -4.0911282026697525e-06 0.0021200000000000004 -6.5421480492599457e-07 0.0021300000000000004 -1.9422724788099328e-06 0.00214 7.1112235916868145e-06 0.00215 7.4329422953865861e-07 0.00216 -3.8617557623297417e-06 0.0021700000000000001 -1.0323702605792326e-06 0.0021800000000000001 4.9340289518991244e-07 0.0021900000000000001 4.9982914611255137e-06 0.0022000000000000001 -1.2686926576902281e-06 0.0022100000000000002 2.1821337860910178e-07 0.0022200000000000002 9.6835156063800719e-07 0.0022300000000000002 2.9147843858316915e-06 0.0022400000000000002 -1.0280205189846479e-05 0.0022500000000000003 -8.0978351570733136e-07 0.0022600000000000003 -6.7159738960262723e-06 0.0022700000000000003 5.4532462917691498e-07 0.0022800000000000003 -1.2858580698381964e-06 0.0022900000000000004 -9.8293928527758904e-07 0.0023000000000000004 -6.384412424621255e-06 0.00231 -2.1981246537841832e-06 0.00232 4.2968485953466985e-06 0.00233 3.8010581879287813e-06 0.0023400000000000001 -3.3506720036489769e-06 0.0023500000000000001 -8.3496823574990529e-07 0.0023600000000000001 -1.9376642694026172e-06 0.0023700000000000001 -4.3384549794400915e-06 0.0023800000000000002 -7.3155855244576094e-07 0.0023900000000000002 1.0495467673488078e-05 0.0024000000000000002 3.7418109441094458e-06 0.0024100000000000002 1.082746350958602e-06 0.0024200000000000003 -5.6972433903391778e-08 0.0024300000000000003 -7.6831691728135217e-06 0.0024400000000000003 -4.7620353520990349e-06 0.0024500000000000004 -1.2210904181488451e-06 0.0024600000000000004 -8.2327340959764982e-06 0.0024700000000000004 -2.7255817200112066e-06 0.00248 -2.9509674065222821e-06 0.00249 4.5633762587701345e-06 0.0025000000000000001 -1.1052168190902695e-06 0.0025100000000000001 -4.8757315850669049e-06 0.0025200000000000001 3.5897143867447846e-06 0.0025300000000000001 -4.8696890560584218e-06 0.0025400000000000002 -2.3978185702899927e-06 0.0025500000000000002 -2.185014185438248e-06 0.0025600000000000002 -7.0981603141699003e-06 0.0025700000000000002 -4.6393541440264559e-06 0.0025800000000000003 -1.0032507351872143e-05 0.0025900000000000003 7.3625694738554035e-06 0.0026000000000000003 7.2635555688205784e-06 0.0026100000000000003 -7.6800960437263838e-06 0.0026200000000000004 1.1695420451339535e-06 0.0026300000000000004 5.5174666251241416e-06 0.0026400000000000004 6.6322360200083005e-06 0.00265 5.3107823324094565e-06 0.00266 -7.1096224755836607e-06 0.0026700000000000001 -1.9794523592776417e-06 0.0026800000000000001 -1.2644278085564301e-06 0.0026900000000000001 1.7287547554715938e-06 0.0027000000000000001 -4.4547091753145447e-06 0.0027100000000000002 3.9344098406737106e-06 0.0027200000000000002 6.8173840070525612e-06 0.0027300000000000002 -5.1890115643267792e-06 0.0027400000000000002 -9.4867721967681817e-06 0.0027500000000000003 9.1773025833446144e-06 0.0027600000000000003 -2.344140656870324e-06 0.0027700000000000003 4.0776045037952003e-07 0.0027800000000000004 4.9039996695855816e-07 0.0027900000000000004 -3.1526284551598026e-06 0.0028000000000000004 3.4696513705388074e-06 0.0028100000000000004 7.4609174328038238e-06 0.00282 4.267221659647383e-07 0.0028300000000000001 3.6152378586252692e-06 0.0028400000000000001 8.819694684958097e-06 0.0028500000000000001 8.2959573640489828e-06 0.0028600000000000001 -1.4286052664310244e-06 0.0028700000000000002 1.1836110462202546e-06 0.0028800000000000002 -4.3159407478097611e-06 0.0028900000000000002 -3.0087255506641533e-06 0.0029000000000000002 -3.4975114783152249e-06 0.0029100000000000003 2.6764208948968466e-06 0.0029200000000000003 2.9410068762883027e-06 0.0029300000000000003 1.1093072814748089e-06 0.0029400000000000003 4.1154874166953369e-06 0.0029500000000000004 2.6627869127958867e-06 0.0029600000000000004 -1.8904201390716182e-06 0.0029700000000000004 5.6416296407748626e-06 0.0029800000000000004 1.6141748558064879e-06 0.00299 1.0383409750307462e-05 0.0030000000000000001 1.0858283062132951e-05 0.0030100000000000001 -1.5671491331370152e-06 0.0030200000000000001 -4.0868280178745385e-06 0.0030300000000000001 -4.1591318859628775e-06 0.0030400000000000002 -1.3541506555509015e-06 0.0030500000000000002 6.863148796753429e-06 0.0030600000000000002 -5.0096063057484203e-06 0.0030700000000000002 -8.5653888693617279e-07 0.0030800000000000003 5.8139379631639455e-07 0.0030900000000000003 9.2066958691702448e-07 0.0031000000000000003 3.5919695817176222e-06 0.0031100000000000004 -6.7473047525711476e-06 0.0031200000000000004 2.4641445526097901e-07 0.0031300000000000004 2.8987188149674854e-06 0.0031400000000000004 -2.829262353177535e-06 0.0031500000000000005 -4.25350536080311e-06 0.00316 -7.9913081646757021e-07 0.0031700000000000001 5.3202291858796359e-06 0.0031800000000000001 -2.4988732910805072e-06 0.0031900000000000001 -6.6015045620615146e-06 0.0032000000000000002 1.4915933368505044e-05 0.0032100000000000002 -2.9267723621777765e-06 0.0032200000000000002 -7.1999730208626426e-06 0.0032300000000000002 -1.9957950688401372e-06 0.0032400000000000003 9.2247498544615899e-07 0.0032500000000000003 -1.330199989481245e-06 0.0032600000000000003 3.0907014643394736e-06 0.0032700000000000003 -2.2239279514788708e-06 0.0032800000000000004 -5.6322825061772612e-06 0.0032900000000000004 1.0005469920791358e-05 0.0033000000000000004 -2.5788680188856833e-06 0.0033100000000000004 7.5680474730556881e-06 0.0033200000000000005 -5.149671316005768e-06 0.0033300000000000001 5.083338836584213e-06 0.0033400000000000001 2.3727241838134501e-06 0.0033500000000000001 -9.7476952716958475e-07 0.0033600000000000001 -2.5348350437609774e-06 0.0033700000000000002 4.813454384061018e-06 0.0033800000000000002 -8.4856630037160178e-07 0.0033900000000000002 8.811044614266426e-06 0.0034000000000000002 -1.2666035162843108e-06 0.0034100000000000003 -2.6350297864094956e-06 0.0034200000000000003 -2.9112877376868064e-06 0.0034300000000000003 1.9811349675257515e-06 0.0034400000000000003 -1.0941870117439724e-06 0.0034500000000000004 8.301356107348517e-07 0.0034600000000000004 -5.2742330106437208e-06 0.0034700000000000004 8.7168186372211032e-07 0.0034800000000000005 -2.1133643521171948e-07 0.0034900000000000005 -1.1309393853729633e-05 0.0035000000000000001 -1.8907031960892825e-06 0.0035100000000000001 -2.1135019961933262e-06 0.0035200000000000001 -3.0341223348310152e-07 0.0035300000000000002 4.3247478266635283e-06 0.0035400000000000002 8.0593616734135597e-07 0.0035500000000000002 5.4977717586661003e-06 0.0035600000000000002 4.8431173795390254e-06 0.0035700000000000003 -6.430192330500476e-07 0.0035800000000000003 3.4015824100955069e-06 0.0035900000000000003 7.5553868863442306e-06 0.0036000000000000003 3.7596960057321581e-07 0.0036100000000000004 6.8816787343739687e-07 0.0036200000000000004 2.4405903027425207e-06 0.0036300000000000004 -2.1501838453540809e-06 0.0036400000000000004 -3.2658783988416811e-06 0.0036500000000000005 2.5452989442394909e-06 0.0036600000000000005 4.2027320562443256e-06 0.0036700000000000001 4.7028713334903775e-07 0.0036800000000000001 -2.6489583315655949e-06 0.0036900000000000001 -3.3427184111376748e-06 0.0037000000000000002 -3.199871622656231e-06 0.0037100000000000002 -6.3219561839639278e-08 0.0037200000000000002 -4.2623913778881255e-06 0.0037300000000000002 -1.532784382072635e-06 0.0037400000000000003 -7.2647814418808874e-06 0.0037500000000000003 -2.7234398453768192e-06 0.0037600000000000003 1.5117708128694733e-06 0.0037700000000000003 8.1642889227002279e-06 0.0037800000000000004 1.5650658261922064e-06 0.0037900000000000004 -1.28138252315504e-06 0.0038000000000000004 4.3439405090239305e-07 0.0038100000000000005 4.9107298625865826e-06 0.0038200000000000005 -1.3392008824678147e-06 0.0038300000000000005 -1.1800269237662784e-05 0.0038400000000000005 1.4710694170069907e-06 0.0038500000000000001 -4.0024500405092068e-06 0.0038600000000000001 -9.2452865741306083e-06 0.0038700000000000002 -1.1233093651874539e-05 0.0038800000000000002 -1.2051676708189747e-06 0.0038900000000000002 -1.229105747112945e-05 0.0039000000000000003 -7.151048273937684e-06 0.0039100000000000003 6.4073667113393941e-06 0.0039200000000000007 1.3662894575850287e-05 0.0039300000000000003 1.3947775969661656e-06 0.0039399999999999999 1.5316199671920757e-06 0.0039500000000000004 3.4758827322449998e-07 0.00396 2.9086882197404974e-07 0.0039700000000000004 2.9309860946431222e-06 0.00398 8.5112150575758128e-06 0.0039900000000000005 2.7085044353616184e-06 0.0040000000000000001 -1.6895977786276621e-06 0.0040100000000000005 9.9308958660794501e-06 0.0040200000000000001 1.3260994987003717e-06 0.0040300000000000006 1.5105415846207033e-06 0.0040400000000000002 3.8833073826159188e-06 0.0040500000000000006 -6.069752511072641e-07 0.0040600000000000002 1.0748278043687544e-05 0.0040700000000000007 -3.7966616117162944e-06 0.0040800000000000003 -5.0001121412275474e-06 0.0040900000000000008 4.0112356489987344e-06 0.0041000000000000003 1.3616515855177281e-05 0.0041099999999999999 -8.5695251806727747e-06 0.0041200000000000004 4.8540949737758958e-06 0.00413 1.2146360187717016e-06 0.0041400000000000005 -6.1409788803809071e-06 0.00415 3.6852191977771802e-06 0.0041600000000000005 -5.734826266491816e-06 0.0041700000000000001 -3.895840431638949e-06 0.0041800000000000006 2.3653541675859648e-06 0.0041900000000000001 -6.0286690939493122e-06 0.0042000000000000006 5.2671391442555054e-06 0.0042100000000000002 9.3686642336525844e-07 0.0042200000000000007 -1.2288903069890063e-07 0.0042300000000000003 -3.7260891626401835e-07 0.0042400000000000007 5.7455698713059163e-07 0.0042500000000000003 -8.9115687792701576e-06 0.0042600000000000008 -4.5181551387715808e-06 0.0042700000000000004 -5.4843991399916764e-06 0.00428 -5.0103465000073953e-07 0.0042900000000000004 -1.1293636853642439e-06 0.0043 -1.1521390996885364e-06 0.0043100000000000005 3.5381372939887012e-08 0.0043200000000000001 -1.1714729385294335e-06 0.0043300000000000005 6.9773389128322707e-06 0.0043400000000000001 -7.8004066317088648e-06 0.0043500000000000006 -3.1751145190009937e-06 0.0043600000000000002 -8.3412151664619371e-06 0.0043700000000000006 -4.6002910668912229e-06 0.0043800000000000002 8.0586530972155445e-06 0.0043900000000000007 9.769861363135189e-07 0.0044000000000000003 -2.8498853606409192e-06 0.0044100000000000007 1.0072924725896466e-06 0.0044200000000000003 1.7091710859459875e-06 0.0044300000000000008 1.1312216340682528e-06 0.0044400000000000004 2.9331921783851204e-06 0.00445 -5.0854325972789839e-06 0.0044600000000000004 -5.3842880522705988e-06 0.00447 -2.0982132977223314e-06 0.0044800000000000005 -3.1006137855782719e-06 0.0044900000000000001 -5.8621941252895556e-07 0.0045000000000000005 -8.2808572017221259e-06 0.0045100000000000001 3.5014670119775274e-06 0.0045200000000000006 -5.3542359756818506e-06 0.0045300000000000002 -3.0054280058813758e-06 0.0045400000000000006 -7.2932796481706068e-06 0.0045500000000000002 -1.9133820170577762e-06 0.0045600000000000007 -1.0469356088079012e-06 0.0045700000000000003 2.9887776554759614e-06 0.0045800000000000007 -5.5098044939643526e-07 0.0045900000000000003 -9.7219009790488402e-06 0.0046000000000000008 -3.5869529385078855e-06 0.0046100000000000004 3.1646889332648036e-08 0.00462 -5.8372798578666012e-06 0.0046300000000000004 -5.276615701042519e-06 0.00464 -3.0338452568284769e-06 0.0046500000000000005 -2.0439142353450851e-06 0.0046600000000000001 -1.1706469514157666e-06 0.0046700000000000005 -4.0083272383946455e-06 0.0046800000000000001 -5.2267057094006116e-06 0.0046900000000000006 2.0200653251195734e-06 0.0047000000000000002 -4.4853436078695814e-07 0.0047100000000000006 -7.6240863570817259e-06 0.0047200000000000002 2.6423487536392806e-06 0.0047300000000000007 1.2832449386406066e-06 0.0047400000000000003 -6.454669105838468e-06 0.0047500000000000007 6.9464035729772303e-06 0.0047600000000000003 3.7188030040382204e-06 0.0047700000000000008 4.2954880310027327e-07 0.0047800000000000004 -1.105820944476442e-05 0.00479 1.1188640374659741e-06 0.0048000000000000004 -3.6177098142273558e-06 0.00481 3.7835691414628424e-06 0.0048200000000000005 5.7758613087157071e-06 0.0048300000000000001 -2.5567914767183265e-06 0.0048400000000000006 -1.6544057534114681e-06 0.0048500000000000001 4.421192564282437e-06 0.0048600000000000006 -1.6703865982055764e-06 0.0048700000000000002 2.4670888032814028e-06 0.0048800000000000007 -8.936657390044538e-06 0.0048900000000000002 1.2786976013528784e-06 0.0049000000000000007 1.4925558101834863e-06 0.0049100000000000003 -6.9461499816781594e-07 0.0049200000000000008 -8.6725984839278749e-06 0.0049300000000000004 1.9462843687672521e-06 0.0049400000000000008 -4.4488591155201425e-06 0.0049500000000000004 -6.3754688243288374e-06 0.00496 1.9168608936694361e-06 0.0049700000000000005 -2.3191640089997801e-06 0.0049800000000000001 -3.7310369945268e-06 0.0049900000000000005 6.1641835021751858e-06 0.0050000000000000001 -8.557490032667616e-07 0.0050100000000000006 8.3384693263693756e-06 0.0050200000000000002 -5.879710425791477e-08 0.0050300000000000006 2.1833512002845719e-06 0.0050400000000000002 -3.0350984785120985e-06 0.0050500000000000007 -1.3946005930712951e-06 0.0050600000000000003 5.666035005154832e-06 0.0050700000000000007 -2.7253875215786668e-06 0.0050800000000000003 -1.2338555056473843e-06 0.0050900000000000008 -1.9529006550247578e-06 0.0051000000000000004 3.0550741907439994e-06 0.0051100000000000008 3.1134321498563793e-06 0.0051200000000000004 1.996771498136932e-06 0.00513 -3.9868634619772865e-06 0.0051400000000000005 2.4105546478685914e-06 0.0051500000000000001 -1.6118934770227248e-06 0.0051600000000000005 3.2490177282086743e-06 0.0051700000000000001 -9.540092385459502e-06 0.0051800000000000006 -2.4523056345193012e-06 0.0051900000000000002 -5.8843041899436349e-06 0.0052000000000000006 -7.4064826507551109e-06 0.0052100000000000002 -6.8250493270337871e-06 0.0052200000000000007 -1.4183694517441308e-06 0.0052300000000000003 1.2400951503429479e-06 0.0052400000000000007 -2.0380513451416138e-06 0.0052500000000000003 1.4656274731459875e-08 0.0052600000000000008 -3.6346971216743633e-06 0.0052700000000000004 9.3611878459216368e-07 0.0052800000000000008 -9.2363314765544254e-08 0.0052900000000000004 1.6793690695398953e-06 0.0053 -4.7531111112216919e-06 0.0053100000000000005 -8.7884458224138501e-06 0.0053200000000000001 -5.2658480814284334e-06 0.0053300000000000005 -1.982446910241473e-06 0.0053400000000000001 -4.8263394015609899e-07 0.0053500000000000006 -9.997496789943851e-06 0.0053600000000000002 -1.1541205706707537e-06 0.0053700000000000006 -7.9031488601569169e-07 0.0053800000000000002 8.7558140503436709e-06 0.0053900000000000007 5.1116916281775591e-07 0.0054000000000000003 6.755963630752176e-06 0.0054100000000000007 -1.647982646584802e-06 0.0054200000000000003 -1.9192805721955851e-05 0.0054300000000000008 -9.3403955570614661e-06 0.0054400000000000004 1.0843260281596306e-05 0.0054500000000000009 -4.9479560379077766e-06 0.0054600000000000004 1.4727009920342577e-06 0.00547 -8.2810752329795878e-06 0.0054800000000000005 -8.0261858586590794e-06 0.0054900000000000001 6.8443455010096075e-06 0.0055000000000000005 5.2340486076521104e-06 0.0055100000000000001 5.6100630157939842e-06 0.0055200000000000006 3.8315251318602503e-06 0.0055300000000000002 1.2853882169434908e-06 0.0055400000000000007 -4.2732431976731336e-06 0.0055500000000000002 -3.3112367270867562e-06 0.0055600000000000007 2.4939399039375054e-06 0.0055700000000000003 2.9757087973258474e-06 0.0055800000000000008 -3.6288147771841361e-06 0.0055900000000000004 1.6326019096670767e-06 0.0056000000000000008 -1.9976183161271893e-06 0.0056100000000000004 -9.2033737160407366e-07 0.0056200000000000009 5.1403716238196696e-06 0.0056300000000000005 5.3613218203626836e-07 0.00564 7.3358066378871776e-06 0.0056500000000000005 3.9518734564154041e-06 0.0056600000000000001 4.0431430513048809e-06 0.0056700000000000006 6.7171352314620709e-06 0.0056800000000000002 5.7444729706331883e-06 0.0056900000000000006 -1.0286508617255959e-06 0.0057000000000000002 -1.4921133091717511e-07 0.0057100000000000007 1.5089455904333438e-06 0.0057200000000000003 -1.2971991539585305e-06 0.0057300000000000007 1.740518484693946e-06 0.0057400000000000003 -1.2106169726089095e-05 0.0057500000000000008 7.9324462594900321e-06 0.0057600000000000004 -1.2621941173024847e-06 0.0057700000000000008 8.0503027092441278e-06 0.0057800000000000004 2.675344496891169e-06 0.0057900000000000009 -2.0026605699391964e-06 0.0058000000000000005 -1.5305091611353549e-06 0.0058100000000000001 -7.1751858335578382e-06 0.0058200000000000005 5.7694461044259285e-06 0.0058300000000000001 -8.4633255256488426e-06 0.0058400000000000006 6.5189363734127042e-06 0.0058500000000000002 3.1500063064346064e-06 0.0058600000000000006 1.1541791444867306e-06 0.0058700000000000002 2.5637372645140653e-06 0.0058800000000000007 -4.6434090156321683e-06 0.0058900000000000003 6.6552124662945705e-06 0.0059000000000000007 -4.948493716498056e-06 0.0059100000000000003 -5.5293825253480882e-06 0.0059200000000000008 -4.1409224596841408e-06 0.0059300000000000004 1.6800232389702348e-06 0.0059400000000000008 7.9202345329134858e-07 0.0059500000000000004 2.2943911876233514e-06 0.0059600000000000009 -2.1519818992548764e-06 0.0059700000000000005 1.1386167099057814e-06 0.0059800000000000001 -6.6652468288515368e-06 0.0059900000000000005 8.765045335101387e-06 0.0060000000000000001 4.9019845548684005e-06 0.0060100000000000006 -3.3740028694110561e-06 0.0060200000000000002 1.0438323465867985e-05 0.0060300000000000006 1.1587365786695236e-06 0.0060400000000000002 -8.3659189981003435e-07 0.0060500000000000007 -1.1482283868161644e-07 0.0060600000000000003 -3.980763330619158e-06 0.0060700000000000007 1.0183738298206734e-05 0.0060800000000000003 8.8609225493617107e-06 0.0060900000000000008 6.8035163281023844e-06 0.0061000000000000004 -6.2109870325177361e-06 0.0061100000000000008 -9.7999928566886324e-06 0.0061200000000000004 -7.9936145115856748e-06 0.0061300000000000009 3.7188799425526974e-06 0.0061400000000000005 2.73000152164303e-07 0.0061500000000000001 -2.3698975787779115e-06 0.0061600000000000005 2.8085074595923009e-06 0.0061700000000000001 1.9543356909267575e-06 0.0061800000000000006 8.949259434942464e-06 0.0061900000000000002 -4.6399797279254363e-06 0.0062000000000000006 2.8301277001115457e-06 0.0062100000000000002 2.6490066811704607e-06 0.0062200000000000007 -6.0375881880078676e-06 0.0062300000000000003 3.2302168711384868e-06 0.0062400000000000008 2.7879590202168606e-06 0.0062500000000000003 6.8936397585691798e-06 0.0062600000000000008 -2.9600363846043829e-06 0.0062700000000000004 -8.4873810434433612e-08 0.0062800000000000009 -5.0954694255216174e-06 0.0062900000000000005 -1.6060761476999973e-06 0.0063000000000000009 -3.0211366049661605e-06 0.0063100000000000005 7.2994460837011259e-06 0.0063200000000000001 5.7400248235346176e-06 0.0063300000000000006 2.156456471692417e-06 0.0063400000000000001 -2.9514554766660985e-06 0.0063500000000000006 -2.9614353313382195e-07 0.0063600000000000002 -2.7969619698071119e-06 0.0063700000000000007 2.4574932441704228e-06 0.0063800000000000003 -2.2624369515809122e-06 0.0063900000000000007 -2.1420150336160998e-06 0.0064000000000000003 7.5061671811848256e-06 0.0064100000000000008 -2.5928580663249971e-06 0.0064200000000000004 3.1351775251100779e-07 0.0064300000000000008 5.5681877948429815e-06 0.0064400000000000004 2.8827485838900441e-06 0.0064500000000000009 5.7507512537725654e-06 0.0064600000000000005 -2.3163889309922735e-07 0.0064700000000000009 -5.6825909131179646e-06 0.0064800000000000005 -1.7915408682200534e-06 0.0064900000000000001 8.1376163525576753e-07 0.0065000000000000006 3.1343654722075969e-06 0.0065100000000000002 1.3924227382154281e-06 0.0065200000000000006 -8.9386858515369012e-06 0.0065300000000000002 5.5604510322032682e-06 0.0065400000000000007 1.0605700687178673e-05 0.0065500000000000003 7.9334902143673495e-06 0.0065600000000000007 -2.4396341178755732e-06 0.0065700000000000003 -2.6188653094139275e-06 0.0065800000000000008 -5.7850962328497229e-06 0.0065900000000000004 2.0649840497604456e-06 0.0066000000000000008 6.7834199852174123e-06 0.0066100000000000004 5.8813550807938806e-06 0.0066200000000000009 -2.1368325027009998e-06 0.0066300000000000005 -6.6249695020549004e-07 0.0066400000000000009 -6.8040391853803929e-06 0.0066500000000000005 -8.2334678518120926e-07 0.0066600000000000001 -5.8476983572182675e-06 0.0066700000000000006 -2.2030174449359363e-06 0.0066800000000000002 -3.0731950639878137e-06 0.0066900000000000006 8.2895876890098001e-06 0.0067000000000000002 -4.4683103116722086e-06 0.0067100000000000007 4.9576207298101369e-06 0.0067200000000000003 2.328684468084297e-06 0.0067300000000000007 -5.7487792877310833e-06 0.0067400000000000003 9.2980923373160195e-07 0.0067500000000000008 -4.3271609987515749e-06 0.0067600000000000004 -9.4375028326561227e-06 0.0067700000000000008 7.6725157662922683e-06 0.0067800000000000004 6.2048740397029548e-07 0.0067900000000000009 9.5871726493003499e-06 0.0068000000000000005 -7.7394280675142356e-06 0.0068100000000000009 1.4412121773851902e-06 0.0068200000000000005 7.1892518238847397e-07 0.0068300000000000001 -1.929080105721526e-06 0.0068400000000000006 6.1013684689120691e-06 0.0068500000000000002 2.2447609960832583e-06 0.0068600000000000006 -6.2012916549866759e-07 0.0068700000000000002 -1.2314002967351272e-07 0.0068800000000000007 -8.2783331085227858e-07 0.0068900000000000003 5.1853595129713122e-06 0.0069000000000000008 -3.3734247793609732e-06 0.0069100000000000003 1.9871043145827017e-06 0.0069200000000000008 4.2930299722144986e-07 0.0069300000000000004 1.0427219048943682e-05 0.0069400000000000009 -8.612062442963534e-09 0.0069500000000000004 -4.472983653469967e-06 0.0069600000000000009 -2.6718690232226568e-06 0.0069700000000000005 -8.3234603926505843e-06 0.006980000000000001 -3.2864468290120168e-06 0.0069900000000000006 4.8809349740401021e-06 0.0070000000000000001 -1.4816260842362365e-06 0.0070100000000000006 6.6645534728556518e-06 0.0070200000000000002 7.0290857873007958e-07 0.0070300000000000007 -7.8385982765790435e-06 0.0070400000000000003 -1.0049511176621736e-05 0.0070500000000000007 8.0172058391823465e-06 0.0070600000000000003 3.1885090825561245e-07 0.0070700000000000008 -7.5505863162351568e-06 0.0070800000000000004 -1.915642598631298e-06 0.0070900000000000008 -4.1524941609465129e-07 0.0071000000000000004 6.9976568405745696e-06 0.0071100000000000009 2.734887899211129e-06 0.0071200000000000005 3.6839967751762939e-06 0.0071300000000000009 -1.0504249243717868e-05 0.0071400000000000005 -8.8465785965445312e-06 0.007150000000000001 1.3166951545219445e-06 0.0071600000000000006 -3.0007673606073433e-06 0.0071700000000000002 9.4006626952234172e-06 0.0071800000000000006 5.522413165020212e-06 0.0071900000000000002 1.2020016180443054e-06 0.0072000000000000007 -2.5344129007274567e-07 0.0072100000000000003 -1.104640341733985e-05 0.0072200000000000007 4.2510546018470948e-07 0.0072300000000000003 -6.2933560295209043e-06 0.0072400000000000008 3.4665996357578895e-06 0.0072500000000000004 -5.5106010248394286e-07 0.0072600000000000008 -3.4962896493942311e-06 0.0072700000000000004 1.1264335697287882e-05 0.0072800000000000009 2.5311891426696683e-06 0.0072900000000000005 3.8427981829552154e-06 0.0073000000000000009 1.0475747669454813e-06 0.0073100000000000005 -4.8674132833826685e-06 0.007320000000000001 -5.6619276793542462e-06 0.0073300000000000006 2.1679642875029601e-06 0.0073400000000000002 -6.0347367919877583e-06 0.0073500000000000006 5.709510463852269e-06 0.0073600000000000002 -5.935664707928386e-06 0.0073700000000000007 2.7441960111542552e-06 0.0073800000000000003 1.6562340641300689e-06 0.0073900000000000007 -8.0756922152373705e-08 0.0074000000000000003 1.5361926496746301e-06 0.0074100000000000008 3.1035265174682207e-06 0.0074200000000000004 1.0267142304605051e-07 0.0074300000000000008 4.3846701492543824e-06 0.0074400000000000004 -9.4392362806606743e-07 0.0074500000000000009 -2.5183296379299076e-07 0.0074600000000000005 -5.0354828043955417e-06 0.0074700000000000009 -6.5752354805398197e-07 0.0074800000000000005 -4.7295726550367536e-06 0.007490000000000001 6.8442510782386147e-06 0.0075000000000000006 -6.1337251037635269e-06 0.0075100000000000002 -1.4380588391511085e-06 0.0075200000000000006 -5.683882349306211e-06 0.0075300000000000002 6.7476739660057374e-06 0.0075400000000000007 1.4196041645505352e-06 0.0075500000000000003 5.6565505789577989e-06 0.0075600000000000007 -5.8051038242439819e-06 0.0075700000000000003 -4.7905264330344884e-06 0.0075800000000000008 -2.2617365965418953e-06 0.0075900000000000004 2.3556163245411346e-07 0.0076000000000000009 -4.5640213845027474e-06 0.0076100000000000004 4.6121768462385005e-06 0.0076200000000000009 -1.8294109643073346e-07 0.0076300000000000005 2.1446882726424446e-06 0.007640000000000001 -1.3218998171748168e-08 0.0076500000000000005 3.8296085084436272e-06 0.007660000000000001 5.254276517036442e-06 0.0076700000000000006 4.2061386267097048e-06 0.0076800000000000011 -1.2626754788906369e-06 0.0076900000000000007 -4.7892226097840537e-07 0.0077000000000000002 4.73611633412904e-06 0.0077100000000000007 -8.9669241957670352e-06 0.0077200000000000003 9.259303450834812e-06 0.0077300000000000008 3.5347063695403968e-06 0.0077400000000000004 -7.8335893029796455e-06 0.0077500000000000008 7.7118883157110518e-06 0.0077600000000000004 1.4108150156237646e-06 0.0077700000000000009 1.8401468341577566e-09 0.0077800000000000005 -6.8276425630118093e-06 0.0077900000000000009 1.2101822891642908e-06 0.0078000000000000005 3.0123104225352429e-06 0.007810000000000001 -3.0182190092011322e-06 0.0078200000000000006 4.0460439716882476e-06 0.0078300000000000002 5.3090047668546491e-07 0.0078400000000000015 6.1931904876494762e-07 0.0078500000000000011 3.6748004384033254e-06 0.0078600000000000007 -6.2493204845266366e-07 0.0078700000000000003 1.0862265750468108e-07 0.0078799999999999999 5.6946023725973194e-07 0.0078900000000000012 -4.1518711534610949e-07 0.0079000000000000008 5.9720195672940493e-06 0.0079100000000000004 -6.6945329125814805e-06 0.00792 2.276912512317075e-08 0.0079300000000000013 -8.9114898641417872e-06 0.0079400000000000009 -4.0866249931270231e-06 0.0079500000000000005 -1.3152831228366103e-06 0.0079600000000000001 5.8574431729583444e-06 0.0079700000000000014 5.8889518517351651e-06 0.007980000000000001 -2.4467318559276242e-06 0.0079900000000000006 3.1270060302065959e-06 0.0080000000000000002 -2.4257226242941701e-06 0.0080100000000000015 2.8788781037671818e-07 0.0080200000000000011 -2.2095685642641272e-06 0.0080300000000000007 -1.5111637772542503e-06 0.0080400000000000003 -1.7222569750651441e-06 0.0080499999999999999 6.0197532533634619e-06 0.0080600000000000012 1.2170875643154238e-05 0.0080700000000000008 4.4097059921048915e-06 0.0080800000000000004 -6.6937546589481541e-06 0.00809 -7.1881325108245792e-06 0.0081000000000000013 -5.1731264884731967e-06 0.0081100000000000009 -1.0577127762803633e-05 0.0081200000000000005 4.3951564560787888e-06 0.0081300000000000001 7.8119159406722311e-06 0.0081400000000000014 5.7024645564847127e-06 0.008150000000000001 -5.5285236317535836e-06 0.0081600000000000006 1.8183333846604108e-06 0.0081700000000000002 -3.7042056787790311e-06 0.0081800000000000015 -3.9963783057317187e-06 0.0081900000000000011 4.9654195763033138e-06 0.0082000000000000007 6.2974073860807116e-06 0.0082100000000000003 1.0504945296269417e-05 0.0082199999999999999 -3.6532341490327278e-06 0.0082300000000000012 -3.6945830667056881e-06 0.0082400000000000008 -3.192752476107348e-06 0.0082500000000000004 5.0621451650697917e-06 0.00826 -6.0495042624356145e-06 0.0082700000000000013 -6.8055589104709649e-07 0.0082800000000000009 4.0213170410044243e-06 0.0082900000000000005 -5.8010783363789799e-06 0.0083000000000000001 -3.7374613323700654e-06 0.0083100000000000014 -6.1674530766441544e-06 0.008320000000000001 -4.2348797001677112e-06 0.0083300000000000006 -4.7267517083242196e-06 0.0083400000000000002 1.537031384594089e-06 0.0083500000000000015 -1.2262739655326312e-05 0.0083600000000000011 -1.9122017598978175e-06 0.0083700000000000007 -5.4506953702411868e-06 0.0083800000000000003 -1.1917067269034278e-06 0.0083899999999999999 -2.6917852157791815e-07 0.0084000000000000012 -4.0487952196320431e-06 0.0084100000000000008 2.2852123901582461e-06 0.0084200000000000004 -7.6830803129775132e-06 0.00843 1.178910557931769e-06 0.0084400000000000013 2.6407865255091494e-07 0.0084500000000000009 -2.1068290439795897e-06 0.0084600000000000005 -4.43332884748203e-06 0.0084700000000000001 -5.8588410003359284e-06 0.0084800000000000014 -2.1919854939306844e-06 0.008490000000000001 1.1617544162047329e-05 0.0085000000000000006 -2.0128588180425348e-06 0.0085100000000000002 8.3361976403210736e-06 0.0085200000000000015 3.4012915533469664e-06 0.0085300000000000011 6.9380495132166437e-06 0.0085400000000000007 5.3114681584963933e-06 0.0085500000000000003 8.6531483863779683e-06 0.0085599999999999999 6.6339731631788998e-06 0.0085700000000000012 -5.0651125462931814e-06 0.0085800000000000008 3.8632275409080372e-06 0.0085900000000000004 3.9510868931239471e-06 0.0086 -8.3046014572909276e-06 0.0086100000000000013 -4.4230310493765224e-06 0.0086200000000000009 2.4534621579665312e-06 0.0086300000000000005 -2.9192706428296702e-06 0.0086400000000000001 6.0935875755478964e-06 0.0086500000000000014 -2.2711072775117203e-06 0.008660000000000001 -4.377426168116699e-06 0.0086700000000000006 2.5270633792173018e-06 0.0086800000000000002 1.0047918925589581e-05 0.0086900000000000015 5.6194795849183732e-06 0.0087000000000000011 -5.134191143746217e-06 0.0087100000000000007 1.0661230914756346e-05 0.0087200000000000003 3.1328370424268125e-06 0.0087299999999999999 -5.0917047972928712e-06 0.0087400000000000012 5.126526968490939e-06 0.0087500000000000008 -6.7174621147491696e-07 0.0087600000000000004 -4.3292652888476425e-06 0.00877 5.7953892828610407e-06 0.0087800000000000013 4.665713712894498e-06 0.0087900000000000009 6.4517940241259537e-07 0.0088000000000000005 -3.872253242195705e-06 0.0088100000000000001 -6.7033953457197777e-06 0.0088200000000000014 4.1783719979459592e-06 0.008830000000000001 -5.0016987399963942e-06 0.0088400000000000006 -1.7733767867172547e-07 0.0088500000000000002 4.0263726798128041e-06 0.0088600000000000016 7.3889318565389934e-06 0.0088700000000000011 -2.1185142871451585e-06 0.0088800000000000007 1.0855454295899233e-06 0.0088900000000000003 -2.6776134723172009e-06 0.0088999999999999999 -4.7935373175474786e-06 0.0089100000000000013 -6.022317540997674e-06 0.0089200000000000008 3.6449393839448689e-06 0.0089300000000000004 -2.2927316545953578e-06 0.00894 3.5712503013779919e-06 0.0089500000000000014 -7.9892388227698141e-06 0.0089600000000000009 -2.0435199090622329e-06 0.0089700000000000005 -2.0797788429739712e-07 0.0089800000000000001 3.9786258266484472e-07 0.0089900000000000015 8.3260054317343025e-06 0.0090000000000000011 2.2689719131791084e-06 0.0090100000000000006 -9.9686563852212548e-06 0.0090200000000000002 4.0768812015414842e-06 0.0090300000000000016 -6.1412612994492691e-06 0.0090400000000000012 -1.2789828529141435e-05 0.0090500000000000008 1.1336025429550592e-05 0.0090600000000000003 -1.0744794022657721e-05 0.0090699999999999999 -3.8729505728659157e-06 0.0090800000000000013 1.9758042338736673e-06 0.0090900000000000009 -1.764070453506371e-06 0.0091000000000000004 -1.0559275436392822e-05 0.00911 7.5365320946127114e-07 0.0091200000000000014 1.5343581227080528e-06 0.009130000000000001 -2.1789567350291143e-06 0.0091400000000000006 -8.8756566922958816e-08 0.0091500000000000001 1.6931001086383947e-05 0.0091600000000000015 -1.452093244828209e-05 0.0091700000000000011 -4.5590065101109384e-06 0.0091800000000000007 -1.29510711333965e-06 0.0091900000000000003 -4.8934249954323957e-06 0.0092000000000000016 2.4906944824407521e-06 0.0092100000000000012 -5.8896185244649581e-08 0.0092200000000000008 -2.7485725315687075e-06 0.0092300000000000004 1.5923383017425691e-06 0.0092399999999999999 2.041190592864413e-06 0.0092500000000000013 -2.2053702191011404e-07 0.0092600000000000009 1.0266777834203973e-06 0.0092700000000000005 -2.5028589449696405e-06 0.0092800000000000001 -5.8597524829250205e-07 0.0092900000000000014 -3.6248443415708623e-06 0.009300000000000001 7.3008864789006181e-07 0.0093100000000000006 -4.0730473967494414e-06 0.0093200000000000002 9.6169827407873434e-06 0.0093300000000000015 -1.3128944553724746e-05 0.0093400000000000011 3.5077900780030158e-07 0.0093500000000000007 -1.3930706575797966e-05 0.0093600000000000003 5.8306943114364686e-06 0.0093700000000000016 5.3064783018362088e-07 0.0093800000000000012 -4.7532583070151673e-06 0.0093900000000000008 -6.6429210650652851e-06 0.0094000000000000004 4.9375203292552882e-06 0.00941 -4.9143117576261876e-06 0.0094200000000000013 -4.4277415424269361e-06 0.0094300000000000009 -1.554069193372365e-06 0.0094400000000000005 3.1591628642239679e-06 0.0094500000000000001 -8.4644971593994442e-06 0.0094600000000000014 -2.6445318705170446e-06 0.009470000000000001 8.5930846260743658e-09 0.0094800000000000006 1.2999017614950031e-06 0.0094900000000000002 -3.0531143735437562e-06 0.0095000000000000015 2.1603887308512013e-06 0.0095100000000000011 2.4019946357203386e-06 0.0095200000000000007 -3.3152682147087141e-06 0.0095300000000000003 3.1792677835992795e-06 0.0095400000000000016 -2.6180675094976981e-06 0.0095500000000000012 -1.0059675061625943e-05 0.0095600000000000008 -7.1471235520435638e-07 0.0095700000000000004 -7.7338564496257003e-06 0.00958 -1.5295320125954345e-05 0.0095900000000000013 -1.0279399040981742e-05 0.0096000000000000009 1.1844265618024955e-06 0.0096100000000000005 -7.6132050471749913e-07 0.0096200000000000001 -4.9322740246457076e-06 0.0096300000000000014 -4.9008155495008304e-06 0.009640000000000001 8.538492002020976e-06 0.0096500000000000006 -1.5222263269565219e-06 0.0096600000000000002 5.8221381761352992e-06 0.0096700000000000015 -2.6309981258091233e-06 0.0096800000000000011 -7.3554252876899277e-06 0.0096900000000000007 9.15886299564486e-06 0.0097000000000000003 3.3047812228093433e-06 0.0097100000000000016 2.4826069937499617e-06 0.0097200000000000012 -8.6076074942978937e-06 0.0097300000000000008 -2.6633827640732314e-06 0.0097400000000000004 1.445833807980589e-06 0.00975 -4.7593268301252241e-06 0.0097600000000000013 2.221682213609027e-07 0.0097700000000000009 -4.3290922480190485e-06 0.0097800000000000005 -7.8895912871479183e-06 0.0097900000000000001 4.3423232969034586e-06 0.0098000000000000014 5.4319760719836136e-06 0.009810000000000001 4.290641526136303e-06 0.0098200000000000006 -4.61043277157633e-06 0.0098300000000000002 -6.0881309604528171e-07 0.0098400000000000015 3.4351053958523499e-06 0.0098500000000000011 -3.7538831148260855e-06 0.0098600000000000007 6.5258047407265045e-06 0.0098700000000000003 -3.4308380638280704e-06 0.0098800000000000016 -4.4414137767899077e-06 0.0098900000000000012 -4.7712417644804655e-06 0.0099000000000000008 -5.1791146174905814e-07 0.0099100000000000004 3.7553236850602555e-06 0.00992 -4.883593028671558e-06 0.0099300000000000013 -8.9023159838999195e-06 0.0099400000000000009 7.5949113851885917e-07 0.0099500000000000005 -7.8367063044792714e-06 0.0099600000000000001 6.0756044483324206e-06 0.0099700000000000014 1.7926160776526643e-06 0.009980000000000001 -7.2764338858984075e-06 0.0099900000000000006 -2.9538967661935395e-06 0.01 -3.1581714518251559e-07 0.010010000000000002 4.4344771968332233e-06 0.010020000000000001 4.7974525616294128e-06 0.010030000000000001 -1.7606903475697753e-06 0.01004 1.9326319266231858e-06 0.010050000000000002 -5.789912540513749e-07 0.010060000000000001 -3.3272636464079598e-06 0.010070000000000001 -3.3471959044768388e-06 0.01008 4.6701975585348094e-06 0.01009 -6.7723659368864291e-06 0.010100000000000001 7.8800952773298413e-06 0.010110000000000001 3.3546338617714238e-06 0.010120000000000001 1.2425368912873545e-05 0.01013 7.7484527688796778e-06 0.010140000000000001 2.7132656940740593e-06 0.010150000000000001 -3.857285291397923e-06 0.010160000000000001 -4.6687870266943589e-06 0.01017 1.2869789541426353e-05 0.010180000000000002 4.7174858518751313e-06 0.010190000000000001 -6.7465324814612434e-06 0.010200000000000001 1.0781724750696197e-06 0.01021 4.4933537105181657e-06 0.010220000000000002 4.2280625162522237e-06 0.010230000000000001 -5.2840463640269608e-06 0.010240000000000001 3.6700297306751705e-06 0.01025 4.634020019807102e-06 0.01026 -5.0212908249255828e-06 0.010270000000000001 -2.688263290694524e-06 0.010280000000000001 2.2367542878370488e-06 0.010290000000000001 7.7825461401185447e-07 0.0103 -3.4355261441026134e-07 0.010310000000000001 -3.5093383955274805e-06 0.010320000000000001 4.2485510693083824e-06 0.010330000000000001 2.5087269003281452e-06 0.01034 3.5089509451619434e-06 0.010350000000000002 -1.2347814005103271e-06 0.010360000000000001 -7.6031709334838115e-06 0.010370000000000001 9.5555418949997021e-06 0.01038 -1.6862107833232355e-06 0.010390000000000002 2.345597984927725e-06 0.010400000000000001 -4.8452631272282472e-06 0.010410000000000001 -1.7866312771845611e-06 0.01042 2.4895770157979677e-06 0.01043 -1.4761645736965288e-06 0.010440000000000001 -1.2800490718151998e-06 0.010450000000000001 8.5338866746285809e-06 0.010460000000000001 2.9728122656232359e-06 0.01047 -1.3309834140726011e-06 0.010480000000000001 3.2525790738994518e-06 0.010490000000000001 8.7246931971826875e-06 0.010500000000000001 -2.2973692629408549e-06 0.01051 -4.4159031978457598e-06 0.010520000000000002 -9.916876438266575e-07 0.010530000000000001 1.1609263300835886e-06 0.010540000000000001 -9.7323922563649777e-08 0.01055 6.8732094909288072e-06 0.010560000000000002 -6.5904633676626919e-06 0.010570000000000001 -1.0764853587717255e-05 0.010580000000000001 1.5943317999851754e-08 0.01059 -3.666358199204103e-06 0.0106 2.9171787108982029e-06 0.010610000000000001 1.6331926222781815e-06 0.010620000000000001 1.3919137404907849e-06 0.010630000000000001 -2.6083413662757685e-06 0.01064 3.8244920898120166e-06 0.010650000000000001 -8.3838601666647896e-06 0.010660000000000001 7.7867680277972101e-07 0.010670000000000001 -8.1434702305950659e-06 0.01068 -4.0551196069982865e-06 0.010690000000000002 -3.9444454125025121e-07 0.010700000000000001 8.5716090337950805e-06 0.010710000000000001 4.5189566106323858e-07 0.01072 6.8964313978780852e-06 0.010730000000000002 -2.0083144828821604e-06 0.010740000000000001 6.2214212208928428e-06 0.010750000000000001 -2.098136017315925e-06 0.01076 -3.8657261740685499e-06 0.01077 2.9709696703171396e-06 0.010780000000000001 1.4817292857295526e-06 0.010790000000000001 -5.4424839150456697e-06 0.010800000000000001 3.2101105109850851e-06 0.01081 2.1241338823690802e-06 0.010820000000000001 -2.4680290004957232e-06 0.010830000000000001 -4.1912546657739342e-06 0.010840000000000001 2.8834354348504666e-06 0.01085 -2.8579495100913525e-06 0.010860000000000002 -6.5105708052985298e-06 0.010870000000000001 -4.582274360699863e-06 0.010880000000000001 -5.5297473026656853e-06 0.01089 -3.2380947589297116e-06 0.010900000000000002 5.239290234014939e-06 0.010910000000000001 6.7770759333800194e-06 0.010920000000000001 -1.7568397276466225e-07 0.01093 6.7524915145797098e-06 0.01094 -2.5263640520044259e-06 0.010950000000000001 -4.0700365492127259e-06 0.010960000000000001 -1.0961538349446304e-05 0.010970000000000001 5.4648025406144276e-06 0.01098 -2.4854938318011309e-06 0.010990000000000002 4.7554300888001938e-06 0.011000000000000001 3.0980111106100857e-06 0.011010000000000001 1.0025427523602217e-06 0.01102 -1.8071131813489245e-06 0.011030000000000002 3.9695545073795685e-06 0.011040000000000001 6.7524816013335571e-06 0.011050000000000001 3.3942814278635055e-06 0.01106 2.5958038247724594e-06 0.011070000000000002 -4.5745926315458291e-06 0.011080000000000001 8.6851257228119853e-06 0.011090000000000001 6.8214483566735624e-06 0.0111 -2.5904371656258183e-06 0.01111 1.1279046677324291e-06 0.011120000000000001 -1.0606316393976942e-06 0.011130000000000001 -2.0091401060146706e-06 0.011140000000000001 2.5388881722988085e-06 0.01115 4.4711430730940487e-06 0.011160000000000002 1.9451541145908646e-06 0.011170000000000001 3.0322098754398899e-06 0.011180000000000001 -3.4322690220329873e-07 0.01119 3.5590403808663738e-06 0.011200000000000002 1.0188345400083876e-05 0.011210000000000001 9.4436280364952688e-06 0.011220000000000001 1.0143704960238137e-05 0.01123 6.9899365180226839e-06 0.011240000000000002 3.0780355890673368e-06 0.011250000000000001 -2.0416329279997767e-07 0.011260000000000001 -9.3180298270883611e-06 0.011270000000000001 -8.4445444644228699e-06 0.01128 -1.5993404811782518e-06 0.011290000000000001 -6.0516122078540376e-06 0.011300000000000001 -9.1564251694271435e-07 0.011310000000000001 5.7340043678363664e-07 0.01132 5.9558226436793398e-06 0.011330000000000002 -5.0240687557195453e-06 0.011340000000000001 7.2327549830582643e-06 0.011350000000000001 -7.4498577698028958e-06 0.01136 -6.1381955412414152e-06 0.011370000000000002 4.8938437373232136e-06 0.011380000000000001 1.8635425468372914e-06 0.011390000000000001 5.2975435518506131e-06 0.0114 -1.2480214263931689e-06 0.011410000000000002 -1.028443889583568e-06 0.011420000000000001 2.5483578418745597e-06 0.011430000000000001 -3.9166223263963494e-06 0.011440000000000001 1.9324418387751645e-07 0.01145 3.2622694713171592e-06 0.011460000000000001 -3.141734194555217e-06 0.011470000000000001 -2.946626674147467e-06 0.011480000000000001 -6.4435944972273702e-06 0.01149 3.9190666714096603e-07 0.011500000000000002 -2.4803259795385864e-06 0.011510000000000001 -7.1615802784388054e-06 0.011520000000000001 5.3855250553249518e-06 0.01153 1.5880262828969333e-05 0.011540000000000002 -6.4184336429147643e-06 0.011550000000000001 6.0639678832276439e-06 0.011560000000000001 1.1952397741214115e-06 0.01157 -2.5507036701004949e-06 0.011580000000000002 -5.6339094075876997e-06 0.011590000000000001 -1.0299161914953792e-06 0.011600000000000001 -1.2433038428026345e-05 0.011610000000000001 -9.6839667232919668e-06 0.01162 -6.976849971729762e-06 0.011630000000000001 -4.1799850318255651e-06 0.011640000000000001 -6.0132519499835354e-06 0.011650000000000001 -4.3570454525635921e-06 0.01166 2.9074593685142366e-07 0.011670000000000002 7.6164693432165407e-06 0.011680000000000001 3.269772992328749e-06 0.011690000000000001 -6.9667998656304881e-07 0.0117 1.658872227187706e-06 0.011710000000000002 3.7634725556326245e-06 0.011720000000000001 -2.3196291396471646e-06 0.011730000000000001 -9.6740933572668168e-06 0.01174 9.2209278100991452e-06 0.011750000000000002 -4.4969188437992314e-06 0.011760000000000001 1.005481185323805e-07 0.011770000000000001 3.8441419874688329e-06 0.011780000000000001 5.686243911280603e-06 0.01179 4.879950003076827e-07 0.011800000000000001 -1.0944099442817714e-06 0.011810000000000001 -1.5276383969330849e-06 0.011820000000000001 5.650329754188711e-07 0.01183 5.5630123240920599e-06 0.011840000000000002 -6.4522446378182599e-06 0.011850000000000001 3.853545761363798e-06 0.011860000000000001 4.7696267417747374e-06 0.01187 9.3338153388579036e-06 0.011880000000000002 4.9776622755123747e-06 0.011890000000000001 1.9321612447026049e-06 0.011900000000000001 6.8343132131855886e-06 0.01191 -4.3856982444942041e-06 0.011920000000000002 -3.1588658668928947e-06 0.011930000000000001 -1.5988507884542141e-06 0.011940000000000001 2.3213272278339326e-06 0.011950000000000001 -5.0276782113897258e-06 0.01196 -5.1980702220882609e-06 0.011970000000000001 -1.0028014963223272e-05 0.011980000000000001 6.755253844008504e-07 0.011990000000000001 -4.2962898203383327e-06 0.012 -8.8508375053087291e-06 0.012010000000000002 4.0644744517930621e-06 0.012020000000000001 2.6287090164516515e-06 0.012030000000000001 5.2203418528879315e-06 0.01204 -2.2672577755470733e-06 0.012050000000000002 -2.0648112597012725e-06 0.012060000000000001 -2.3812714938907909e-06 0.012070000000000001 -3.4871721368139362e-08 0.01208 -3.0012792319483659e-07 0.012090000000000002 1.4753391490641957e-06 0.012100000000000001 -1.2554300053088386e-06 0.012110000000000001 -1.4512599636234373e-06 0.012120000000000001 1.1302748360560736e-06 0.01213 -2.206085794423488e-06 0.012140000000000001 -1.5236141809514113e-05 0.012150000000000001 1.2752063128752267e-05 0.012160000000000001 1.6654559395335576e-06 0.01217 1.016569906483163e-05 0.012180000000000002 -1.0635360667843412e-05 0.012190000000000001 5.2137691030929816e-06 0.012200000000000001 -3.2435900884486126e-06 0.01221 -9.166538942397141e-06 0.012220000000000002 7.9237400955931383e-07 0.012230000000000001 -3.8211009455617828e-06 0.012240000000000001 -6.9641883873495998e-06 0.01225 -7.3715667092784952e-06 0.012260000000000002 -5.9682114481708176e-06 0.012270000000000001 3.6388311195170612e-06 0.012280000000000001 -1.9365453842591899e-06 0.012290000000000001 1.1138750169018519e-06 0.0123 -4.2938445174586098e-06 0.012310000000000001 -2.4111394320584309e-06 0.012320000000000001 -6.2063856819638782e-06 0.012330000000000001 4.8867039650425232e-07 0.01234 1.2488244416026296e-05 0.012350000000000002 6.9630266467721344e-06 0.012360000000000001 -4.9892984927716935e-06 0.012370000000000001 6.8938438865703449e-07 0.01238 5.9004300079781549e-06 0.012390000000000002 -2.3792444973563145e-06 0.012400000000000001 2.3265281205935418e-06 0.012410000000000001 1.7103265075192425e-06 0.01242 -5.1399689812553025e-06 0.012430000000000002 2.6133389235302353e-06 0.012440000000000001 1.1754286185209145e-06 0.012450000000000001 3.2395698777228835e-06 0.012460000000000001 -1.1904512793210656e-06 0.01247 -1.0444092264997634e-05 0.012480000000000002 2.7185175963556844e-07 0.012490000000000001 5.9115919582770468e-06 0.012500000000000001 -1.0967683970036372e-05 0.01251 3.8729510064749868e-06 0.012520000000000002 -1.8068316059636757e-06 0.012530000000000001 1.050599444443293e-06 0.012540000000000001 9.8525644051956924e-06 0.01255 2.5664624092181688e-06 0.012560000000000002 -7.3092100700638143e-06 0.012570000000000001 5.8833320554911537e-07 0.012580000000000001 -7.4901816753401672e-06 0.01259 5.0902415819094618e-06 0.012600000000000002 3.7155516438895994e-06 0.012610000000000001 6.5587300087702791e-06 0.012620000000000001 -4.2489125660869294e-06 0.012630000000000001 -1.1972545575539249e-05 0.01264 -3.0527547848848759e-06 0.012650000000000002 1.1510528743578463e-05 0.012660000000000001 -4.2240674527008798e-07 0.012670000000000001 -3.5919777223356406e-06 0.01268 5.0461216860111562e-06 0.012690000000000002 3.2482187743500294e-06 0.012700000000000001 4.0857810414446966e-06 0.012710000000000001 -2.32548964170431e-06 0.01272 -1.3157082711848887e-06 0.012730000000000002 -4.1565476328101607e-06 0.012740000000000001 3.2166304610792002e-06 0.012750000000000001 8.560671430891954e-07 0.012760000000000001 6.646693247298657e-06 0.012770000000000002 1.2367998704694671e-06 0.012780000000000001 2.6604820964184602e-06 0.012790000000000001 -2.9751482150346485e-06 0.012800000000000001 -4.4293121425520879e-06 0.01281 2.290065559344573e-06 0.012820000000000002 -1.9301984477581476e-06 0.012830000000000001 -1.2407726062605848e-06 0.012840000000000001 3.0155574888032017e-07 0.01285 4.8687448356131023e-07 0.012860000000000002 1.21151916826752e-05 0.012870000000000001 7.0315679832552468e-06 0.012880000000000001 1.1595331766504439e-06 0.01289 2.5641969548793864e-07 0.012900000000000002 7.5858682114762947e-06 0.012910000000000001 2.3538856446806914e-06 0.012920000000000001 -5.7230456559438775e-08 0.012930000000000001 -3.8509045098039791e-06 0.012940000000000002 -3.2241941842733232e-06 0.012950000000000001 9.1229814488694033e-06 0.012960000000000001 -1.9071765458162724e-06 0.012970000000000001 -3.6755766705844407e-06 0.01298 9.8646430016171143e-06 0.012990000000000002 4.7371400407138238e-06 0.013000000000000001 3.7199529983210788e-06 0.013010000000000001 7.3217717628275205e-06 0.01302 -1.7059505768952466e-06 0.013030000000000002 -5.6131381105310076e-06 0.013040000000000001 4.1470866193002142e-06 0.013050000000000001 -4.561671283841041e-06 0.01306 4.7868534388870215e-07 0.013070000000000002 -1.3213722404070206e-06 0.013080000000000001 -1.276045791914736e-06 0.013090000000000001 2.7139520231631791e-07 0.013100000000000001 -1.5787298111153081e-06 0.013110000000000002 -8.7809015329749658e-07 0.013120000000000001 3.4926312774376963e-06 0.013130000000000001 -5.6808240941358525e-06 0.013140000000000001 -2.0501430510704381e-06 0.01315 1.260767322408026e-06 0.013160000000000002 -4.6911298905668883e-06 0.013170000000000001 -3.4539060040058629e-07 0.013180000000000001 1.2258491643926154e-05 0.01319 9.5175068505491738e-06 0.013200000000000002 -4.0340511378831294e-06 0.013210000000000001 4.6009584774528735e-06 0.013220000000000001 -1.3393526991010376e-06 0.01323 -1.163443996569451e-06 0.013240000000000002 7.7394429854922908e-06 0.013250000000000001 3.6512812676964973e-07 0.013260000000000001 -1.7278422106576967e-06 0.013270000000000001 3.546600384284732e-06 0.013280000000000002 -1.9519652177982049e-06 0.013290000000000001 3.4056907968913276e-06 0.013300000000000001 -3.9481465130780507e-06 0.013310000000000001 -3.3178942397995872e-06 0.01332 6.0710781578748864e-06 0.013330000000000002 -5.2474168200010702e-06 0.013340000000000001 -7.950196254756838e-07 0.013350000000000001 -1.5341351273082142e-06 0.01336 -5.4784904588130992e-06 0.013370000000000002 5.6820626313080429e-06 0.013380000000000001 3.1370520146454808e-06 0.013390000000000001 -1.1358779840458338e-06 0.0134 4.1614697229751907e-06 0.013410000000000002 5.5692524635084157e-06 0.013420000000000001 -1.7658565792609048e-06 0.013430000000000001 7.0412579792712563e-06 0.013440000000000001 -5.2641163681624332e-06 0.013450000000000002 3.4691519953280112e-06 0.013460000000000001 -6.4789602913506397e-06 0.013470000000000001 -5.6521020407286163e-06 0.013480000000000001 -9.93694720046136e-07 0.01349 1.1623112375725711e-05 0.013500000000000002 7.7134592591485319e-06 0.013510000000000001 -5.4433193178244389e-06 0.013520000000000001 3.5259083166351782e-06 0.01353 3.1032394135331377e-06 0.013540000000000002 3.0659997614285485e-06 0.013550000000000001 -8.1373485959829226e-06 0.013560000000000001 -1.2115979581961554e-06 0.01357 -2.4994504654938864e-06 0.013580000000000002 -2.1497673949237338e-07 0.013590000000000001 9.3415063309935113e-06 0.013600000000000001 -1.3921033848141354e-06 0.013610000000000001 2.569917389275312e-06 0.013620000000000002 -1.8365062249750146e-06 0.013630000000000001 6.9612133185927509e-07 0.013640000000000001 -7.7896815836727254e-06 0.013650000000000001 -1.4322138560618968e-06 0.01366 -1.3435152490173674e-06 0.013670000000000002 -1.2157719998929569e-05 0.013680000000000001 1.6398180536181607e-06 0.013690000000000001 -7.9621697802678537e-06 0.0137 1.6624876643077478e-05 0.013710000000000002 7.7558981329288472e-06 0.013720000000000001 -3.455930873706375e-06 0.013730000000000001 -7.4576520802417792e-06 0.01374 -1.021520815132341e-05 0.013750000000000002 3.7240686059359621e-06 0.013760000000000001 8.7405108321425553e-07 0.013770000000000001 4.2131764263019986e-07 0.013780000000000001 8.7635737789808273e-07 0.013790000000000002 -6.514789638815291e-06 0.013800000000000002 -1.0611017264002616e-05 0.013810000000000001 -2.5140526274276673e-06 0.013820000000000001 -3.4879084269576465e-06 0.01383 2.3316690923207363e-07 0.013840000000000002 7.44867672124968e-06 0.013850000000000001 4.7111161556020972e-06 0.013860000000000001 -8.7089988069572151e-06 0.01387 6.3839624819597704e-06 0.013880000000000002 5.22876102305647e-07 0.013890000000000001 -2.5765784804139212e-06 0.013900000000000001 5.0191585412771411e-06 0.01391 -9.3905391922862018e-07 0.013920000000000002 2.2427535932900766e-06 0.013930000000000001 8.1793261045055233e-06 0.013940000000000001 7.0662582934361239e-07 0.013950000000000001 -3.8186640879017142e-06 0.013960000000000002 1.4296826763901591e-06 0.013970000000000002 6.9207553697064988e-07 0.013980000000000001 8.8425531684999851e-06 0.013990000000000001 -2.2649982099846695e-06 0.014 -3.4904127378221885e-07 0.014010000000000002 3.08048073880253e-06 0.014020000000000001 1.3421399300610345e-06 0.014030000000000001 -3.463297027453965e-06 0.01404 3.7567737024371409e-06 0.014050000000000002 -1.7941695795804266e-06 0.014060000000000001 2.288892455290385e-06 0.014070000000000001 1.8952749096817627e-06 0.014080000000000001 8.1338305095973888e-07 0.014090000000000002 -4.2720252458098097e-07 0.014100000000000001 9.5340527252591602e-06 0.014110000000000001 -1.9627070113260823e-06 0.014120000000000001 -5.7565662975510463e-07 0.014130000000000002 5.8534346691989706e-06 0.014140000000000002 1.4243284128884402e-06 0.014150000000000001 -1.1422850994778299e-05 0.014160000000000001 -5.4001468286096649e-06 0.01417 -3.8436646446869533e-06 0.014180000000000002 -3.8494317915738315e-06 0.014190000000000001 6.3727535704062369e-07 0.014200000000000001 -1.8593002520469921e-06 0.01421 5.2722896014212322e-06 0.014220000000000002 -3.3413305636425165e-06 0.014230000000000001 -7.8386067291867978e-06 0.014240000000000001 -4.4736181590083396e-07 0.014250000000000001 1.117392300874839e-06 0.014260000000000002 -2.7290343207549884e-06 0.014270000000000001 3.1680995379848017e-06 0.014280000000000001 7.3204209705684335e-06 0.014290000000000001 -3.4133267544396616e-06 0.014300000000000002 3.4245316041954502e-06 0.014310000000000002 -9.2821410943333708e-06 0.014320000000000001 -3.0711012772044322e-06 0.014330000000000001 -2.5718210247613519e-06 0.01434 -4.0620480602057575e-06 0.014350000000000002 -6.5255125944816441e-07 0.014360000000000001 -5.2220789979465086e-07 0.014370000000000001 -2.9706591071417262e-06 0.01438 2.831758495916128e-06 0.014390000000000002 1.3268876857073757e-05 0.014400000000000001 -6.7273539429244426e-06 0.014410000000000001 4.9301083437133253e-06 0.014420000000000001 -1.7872944827013623e-06 0.014430000000000002 3.1493535536087603e-06 0.014440000000000001 -3.5151166002436144e-06 0.014450000000000001 -3.4738118504942637e-06 0.014460000000000001 -3.5154035373246951e-06 0.014470000000000002 2.1923321383364708e-06 0.014480000000000002 8.1316914634998109e-06 0.014490000000000001 1.0783359458686018e-06 0.014500000000000001 2.9322423480177762e-06 0.01451 -1.2134729276847373e-06 0.014520000000000002 1.9388722126636086e-06 0.014530000000000001 7.2590368205015697e-07 0.014540000000000001 -1.2103921231470614e-06 0.01455 1.8328993777286195e-06 0.014560000000000002 3.0600239252738934e-06 0.014570000000000001 -1.3165767234012252e-05 0.014580000000000001 2.7860312634078367e-07 0.014590000000000001 4.5854771199685535e-06 0.014600000000000002 3.4749011818729139e-06 0.014610000000000001 6.5873185204480229e-07 0.014620000000000001 -1.7942032088241765e-06 0.014630000000000001 7.1912760971604696e-06 0.014640000000000002 3.7332458714374508e-06 0.014650000000000002 8.7753083204820246e-06 0.014660000000000001 5.4754321847023063e-06 0.014670000000000001 9.2278634913226357e-07 0.01468 -2.5168217060515178e-06 0.014690000000000002 -2.3752460871364614e-06 0.014700000000000001 -4.7262875258428244e-06 0.014710000000000001 2.9800768919289234e-06 0.01472 -4.4630138825931709e-06 0.014730000000000002 -6.4310429261479944e-06 0.014740000000000001 -5.163802589315103e-07 0.014750000000000001 -5.6611514786970535e-06 0.014760000000000001 -1.5422351502868327e-06 0.014770000000000002 -2.820980949744763e-06 0.014780000000000001 -5.4518036437607447e-06 0.014790000000000001 -4.294446791142077e-06 0.014800000000000001 -1.9347857985210845e-06 0.014810000000000002 9.5888589695475534e-07 0.014820000000000002 4.0290523056546059e-06 0.014830000000000001 3.115147242141992e-06 0.014840000000000001 6.2948228996382897e-06 0.01485 2.498445991320758e-06 0.014860000000000002 -7.4791576482799918e-06 0.014870000000000001 -2.6808996462006615e-06 0.014880000000000001 5.2466709688353615e-06 0.01489 1.1773351573971234e-06 0.014900000000000002 4.9228399140359441e-06 0.014910000000000001 4.0323541981039468e-06 0.014920000000000001 -2.0226473294721542e-07 0.014930000000000001 -2.3572622029502711e-07 0.014940000000000002 -8.1391316872065354e-06 0.014950000000000001 -3.1125225968597106e-06 0.014960000000000001 3.5383012688100553e-06 0.014970000000000001 -7.7541509152444691e-06 0.014980000000000002 -4.6652230440163748e-06 0.014990000000000002 -1.80283161758296e-06 0.015000000000000001 -3.7369570582710097e-06 0.015010000000000001 -2.8514582600261255e-07 0.01502 2.4054251740748039e-06 0.015030000000000002 3.0436946525765692e-06 0.015040000000000001 -2.516094772974428e-06 0.015050000000000001 -8.6318508162678003e-06 0.01506 2.7864290368955739e-06 0.015070000000000002 3.896985632376621e-06 0.015080000000000001 2.040614483469912e-06 0.015090000000000001 3.5603710790686902e-06 0.015100000000000001 -9.7162551902764672e-06 0.015110000000000002 -4.668900728039052e-06 0.015120000000000001 2.9163006374863075e-06 0.015130000000000001 1.2402869252360216e-06 0.015140000000000001 1.6437481355026317e-06 0.015150000000000002 7.4827776018771447e-07 0.015160000000000002 -1.8777801533403914e-06 0.015170000000000001 9.5912649468485878e-07 0.015180000000000001 -2.8392775429484149e-06 0.01519 7.5901133337728061e-06 0.015200000000000002 4.8233869160143265e-06 0.015210000000000001 -1.3892830104780677e-06 0.015220000000000001 3.5301165249982123e-06 0.01523 -1.3907615228594084e-06 0.015240000000000002 5.8219376313922293e-07 0.015250000000000001 1.2229813153378578e-06 0.015260000000000001 3.3019415273257457e-06 0.015270000000000001 3.0334697775204801e-07 0.015280000000000002 -5.9748495010842576e-06 0.015290000000000002 -6.1283224906890589e-07 0.015300000000000001 4.5831913991225453e-07 0.015310000000000001 -3.2611945064702079e-06 0.015320000000000002 -8.0840000906846899e-06 0.015330000000000002 -3.7841343992545777e-06 0.015340000000000001 -9.257311852116166e-07 0.015350000000000001 -4.5719675987620391e-06 0.015360000000000002 -5.6199525764431013e-08 0.015370000000000002 5.5107071618533777e-06 0.015380000000000001 1.4586848153019448e-06 0.015390000000000001 -5.5862933152224738e-06 0.0154 -3.1573415142209213e-06 0.015410000000000002 -7.0577499103809812e-06 0.015420000000000001 2.023840855442255e-06 0.015430000000000001 -1.3641112052664021e-06 0.015440000000000001 -4.5133573540518324e-08 0.015450000000000002 9.0795655744800281e-06 0.015460000000000002 -5.7851999695977989e-06 0.015470000000000001 -2.8818534051906621e-07 0.015480000000000001 1.8252458874323667e-06 0.015490000000000002 -9.6204589011766334e-07 0.015500000000000002 -3.7169976774445171e-06 0.015510000000000001 2.6915012194508365e-06 0.015520000000000001 2.2733109040842909e-06 0.015530000000000002 6.3882901627029842e-07 0.015540000000000002 3.8229670726026551e-06 0.015550000000000001 1.4145529397446466e-06 0.015560000000000001 -3.1374063324669637e-06 0.015570000000000001 1.502508708352551e-06 0.015580000000000002 -5.1249929581453484e-06 0.015590000000000001 -3.6879914366285924e-06 0.015600000000000001 2.2346870586668422e-06 0.015610000000000001 2.2983212236676217e-06 0.015620000000000002 6.6531292198416671e-06 0.015630000000000002 1.0043477745828216e-05 0.015640000000000001 -8.6813855640781203e-06 0.015650000000000001 -5.258501851775815e-06 0.01566 -7.3056391259177724e-06 0.01567 2.2240652397576644e-06 0.015680000000000003 -9.5061318961190166e-06 0.015690000000000003 -1.2915339216996886e-06 0.015700000000000002 -4.6250951224009632e-06 0.015710000000000002 7.941567839987394e-07 0.015720000000000001 6.1660717073353214e-07 0.015730000000000001 -4.8622296205038517e-06 0.015740000000000001 -2.5725527478561326e-06 0.01575 -1.9602994336841604e-06 0.01576 -2.8170695425767531e-06 0.015770000000000003 5.0089546142898307e-06 0.015780000000000002 -8.2746503817794542e-06 0.015790000000000002 4.4296181159180436e-06 0.015800000000000002 3.8073783116967436e-08 0.015810000000000001 -5.3245081998335001e-06 0.015820000000000001 -4.6532945656961921e-06 0.01583 8.2805582074719169e-07 0.01584 -7.5935634677161267e-06 0.015850000000000003 -6.3537955168319628e-06 0.015860000000000003 -5.5600692270799029e-06 0.015870000000000002 6.3914368062073827e-06 0.015880000000000002 -1.5822757790764934e-06 0.015890000000000001 8.9386357151764907e-06 0.015900000000000001 -3.4964246298484691e-06 0.015910000000000001 -3.6308637780667698e-06 0.01592 1.3521003006794229e-06 0.01593 -1.3976713333991002e-06 0.015940000000000003 8.1748543953653483e-06 0.015950000000000002 -9.9103555568463503e-08 0.015960000000000002 -2.3665132845625104e-06 0.015970000000000002 9.0809763950210604e-08 0.015980000000000001 2.9235428275357942e-06 0.015990000000000001 -1.9280603584748748e-06 0.016 1.0595198652929268e-06 0.01601 2.3603663691849744e-06 0.016020000000000003 -5.7864462977910097e-07 0.016030000000000003 -4.9013495728832908e-06 0.016040000000000002 -1.0863433680498064e-07 0.016050000000000002 -1.1839266458260985e-05 0.016060000000000001 3.6032785541170825e-07 0.016070000000000001 -6.7709466582175599e-06 0.016080000000000001 5.3716966330579757e-06 0.01609 2.601877365753368e-06 0.0161 8.1817295612755177e-06 0.016110000000000003 -5.2516032965072473e-06 0.016120000000000002 -1.9241641927935317e-06 0.016130000000000002 1.9090051656641952e-06 0.016140000000000002 4.0245377712004233e-06 0.016150000000000001 -8.9344508017158573e-07 0.016160000000000001 -4.0884701795858616e-06 0.01617 7.4853355219773131e-06 0.01618 -1.0154202866420368e-05 0.016190000000000003 -4.72334675859136e-06 0.016200000000000003 3.087336179910071e-06 0.016210000000000002 -2.8512135677869386e-06 0.016220000000000002 -3.298549324278077e-07 0.016230000000000001 -3.2548036256962921e-06 0.016240000000000001 -3.4436608319369752e-06 0.016250000000000001 4.6853124506054176e-06 0.01626 3.2047763978458425e-06 0.01627 4.7212771859251579e-06 0.016280000000000003 1.3188740316123337e-05 0.016290000000000002 6.1554456695627466e-06 0.016300000000000002 1.1094228967978603e-05 0.016310000000000002 4.5916422275360238e-06 0.016320000000000001 5.4145151516469553e-06 0.016330000000000001 -2.1856628887697299e-06 0.01634 5.624474613294074e-06 0.01635 -1.3406052828791855e-06 0.016360000000000003 1.3015224175096179e-06 0.016370000000000003 -1.3293394163754823e-06 0.016380000000000002 -8.4393273827836582e-06 0.016390000000000002 -3.0460730763159235e-06 0.016400000000000001 -1.98234946887908e-06 0.016410000000000001 -7.8807097709196392e-06 0.016420000000000001 3.6831963651684393e-06 0.01643 4.1327322232790253e-06 0.01644 -8.0449702072808796e-06 0.016450000000000003 7.7128939033028332e-07 0.016460000000000002 -5.0581323001358206e-06 0.016470000000000002 -2.3139132308511264e-07 0.016480000000000002 -3.86364733289709e-06 0.016490000000000001 -3.0956737011252364e-06 0.016500000000000001 1.129166441903439e-06 0.01651 -5.6862122036924928e-06 0.01652 3.7310223109164123e-06 0.016530000000000003 -4.9373208189690343e-07 0.016540000000000003 5.3310844952791218e-06 0.016550000000000002 5.7150875758701943e-06 0.016560000000000002 -3.331055608830025e-07 0.016570000000000001 2.1272882242048253e-06 0.016580000000000001 1.0813416509184411e-05 0.016590000000000001 4.8522396868215602e-06 0.0166 5.258328175879888e-06 0.01661 -3.6612862576102887e-07 0.016620000000000003 3.1997924927106629e-06 0.016630000000000002 9.9613753824869638e-07 0.016640000000000002 -1.2722225216173781e-05 0.016650000000000002 2.9343960725000247e-06 0.016660000000000001 5.462104908646724e-07 0.016670000000000001 -4.5507371905915355e-06 0.01668 4.5990725390558137e-06 0.01669 8.7365887352942506e-06 0.016700000000000003 9.9211773913777549e-07 0.016710000000000003 2.1005202623097604e-06 0.016720000000000002 7.5323643717008178e-06 0.016730000000000002 4.3188526384826781e-06 0.016740000000000001 7.3545953138469238e-06 0.016750000000000001 -2.9919339981130458e-07 0.016760000000000001 8.8122682719872458e-06 0.01677 2.0372560430653506e-06 0.01678 -7.6384466005989011e-07 0.016790000000000003 6.1833429544866792e-07 0.016800000000000002 1.3813659352364086e-06 0.016810000000000002 -2.089312438454761e-06 0.016820000000000002 9.3637383273630473e-06 0.016830000000000001 3.0647519240572191e-06 0.016840000000000001 -3.4685009861881945e-06 0.01685 8.7770765654771669e-08 0.01686 5.0956923293144625e-06 0.016870000000000003 4.7969939253522961e-06 0.016880000000000003 9.0223045632748323e-06 0.016890000000000002 9.1344787741973856e-06 0.016900000000000002 -8.5269057062094846e-06 0.016910000000000001 -7.7186435884774481e-06 0.016920000000000001 3.373593843927352e-06 0.016930000000000001 -1.7994103670388891e-06 0.01694 -4.1776032230172303e-06 0.01695 5.9523376456294808e-06 0.016960000000000003 6.344309017309906e-06 0.016970000000000002 -2.9290002180202242e-06 0.016980000000000002 7.413375247490248e-06 0.016990000000000002 -5.221267815763796e-06 0.017000000000000001 7.1486540718169427e-08 0.017010000000000001 -3.5201817900152025e-06 0.01702 1.3561537416589505e-07 0.01703 -1.3721813856932997e-06 0.017040000000000003 6.3324761562103575e-06 0.017050000000000003 2.4376043013565263e-06 0.017060000000000002 5.0674886590360182e-06 0.017070000000000002 -6.1448398418421507e-06 0.017080000000000001 -1.8261959434996298e-06 0.017090000000000001 -4.8474410251895717e-07 0.017100000000000001 6.6882396677903798e-08 0.01711 1.5506106465409588e-05 0.01712 -6.6528666305884606e-06 0.017130000000000003 3.3878232662911226e-06 0.017140000000000002 6.6299227383490216e-06 0.017150000000000002 3.5650341613342908e-06 0.017160000000000002 1.8197877575568931e-06 0.017170000000000001 -3.676060173590363e-07 0.017180000000000001 -2.2452691289971341e-06 0.01719 3.9714756492008036e-06 0.0172 3.2360215461385856e-06 0.017210000000000003 7.1125213155712369e-06 0.017220000000000003 1.1184339184617743e-05 0.017230000000000002 -1.5982486439731622e-06 0.017240000000000002 9.5772081987530901e-07 0.017250000000000001 3.2168813634603034e-06 0.017260000000000001 -6.9057975452491775e-06 0.017270000000000001 8.1202651106981464e-06 0.01728 -4.5375988612126827e-06 0.01729 -8.0368434810188977e-06 0.017300000000000003 2.3760301156496256e-07 0.017310000000000002 2.6595283696779923e-06 0.017320000000000002 -2.9644385598933967e-06 0.017330000000000002 -1.4491943705195447e-06 0.017340000000000001 4.0723796273720364e-06 0.017350000000000001 4.1549345417878648e-06 0.01736 -1.5375606752155437e-06 0.01737 -5.5997724305786382e-06 0.017380000000000003 7.6644222687393911e-07 0.017390000000000003 1.3690567959632734e-05 0.017400000000000002 -2.3253949429082284e-06 0.017410000000000002 4.4260017617382684e-07 0.017420000000000001 -7.5132768307105884e-06 0.017430000000000001 -1.6135746634858392e-07 0.017440000000000001 -2.7065653976225042e-06 0.01745 -7.3639185603274561e-07 0.01746 -3.4833119289169417e-07 0.017470000000000003 2.0006653373916398e-06 0.017480000000000002 3.3471630868421024e-06 0.017490000000000002 4.3862823883143855e-06 0.017500000000000002 -3.1080448321112715e-06 0.017510000000000001 -2.5236768652680998e-06 0.017520000000000001 -5.9901357212317176e-06 0.01753 -1.7692723943289518e-05 0.01754 -4.113825193642691e-06 0.017550000000000003 -4.3529059307057872e-06 0.017560000000000003 3.3718628979851208e-06 0.017570000000000002 -2.2612465440719621e-06 0.017580000000000002 -2.8073609274085276e-06 0.017590000000000001 -4.0731749589877271e-06 0.017600000000000001 2.4328290773088174e-06 0.017610000000000001 2.7036607989919335e-06 0.01762 -7.0115216131397749e-06 0.01763 -1.8920746107730053e-06 0.017640000000000003 1.1405135013712731e-06 0.017650000000000002 4.9465091908782898e-06 0.017660000000000002 -2.1287706614500858e-06 0.017670000000000002 1.1814025087114003e-06 0.017680000000000001 1.4755108118925543e-07 0.017690000000000001 -2.7182931066300854e-06 0.0177 4.0534052594700005e-06 0.01771 1.13567412155226e-05 0.017720000000000003 -2.3151124487188937e-06 0.017730000000000003 -2.3558510767364352e-07 0.017740000000000002 -3.6757192495256649e-06 0.017750000000000002 -6.5216396626977777e-06 0.017760000000000001 -6.7429526254773673e-07 0.017770000000000001 3.0963948844908147e-06 0.017780000000000001 -5.4489710914407359e-06 0.01779 -2.2649108493391795e-06 0.0178 5.573496047406817e-06 0.017810000000000003 2.9906351836927777e-06 0.017820000000000003 -6.570694805980683e-06 0.017830000000000002 -2.7187252000517332e-06 0.017840000000000002 -3.5704775753263046e-07 0.017850000000000001 4.7841028078698082e-06 0.017860000000000001 5.5287498947284221e-06 0.01787 -4.5475982312107862e-07 0.01788 -5.4047352353940907e-06 0.017890000000000003 1.6113999437740167e-07 0.017900000000000003 6.9301660729822195e-07 0.017910000000000002 5.8294516645655341e-07 0.017920000000000002 -7.3761704076685645e-08 0.017930000000000001 -6.7069123369023518e-06 0.017940000000000001 2.2617882431456985e-06 0.017950000000000001 -5.8631561050399306e-07 0.01796 -4.4737523396087942e-06 0.01797 2.7094298033923864e-06 0.017980000000000003 -9.8750256731831766e-06 0.017990000000000003 -2.1940032903834814e-06 0.018000000000000002 -3.2226054889054582e-06 0.018010000000000002 2.4262961552715379e-07 0.018020000000000001 3.1828859742427305e-07 0.018030000000000001 1.5428721011526245e-07 0.01804 7.6593573597510865e-07 0.01805 -8.9492769177096798e-06 0.018060000000000003 -2.7898758620503054e-06 0.018070000000000003 4.3328225763224205e-06 0.018080000000000002 -3.6225779854241034e-06 0.018090000000000002 -3.4037264421573153e-06 0.018100000000000002 5.9165350802825162e-06 0.018110000000000001 8.4643906569585387e-07 0.018120000000000001 -4.5907012576975288e-06 0.01813 5.6060454449486094e-06 0.01814 -1.164604885508036e-06 0.018150000000000003 -5.9341985822485532e-07 0.018160000000000003 -1.5653993582375727e-06 0.018170000000000002 2.9804218071853233e-08 0.018180000000000002 -1.4823232389269907e-06 0.018190000000000001 -3.0266041251501137e-06 0.018200000000000001 -1.2366518991571217e-06 0.01821 8.5811633993836348e-06 0.01822 -4.7571135550967641e-06 0.018230000000000003 4.0725118256010008e-06 0.018240000000000003 1.5001086494652794e-06 0.018250000000000002 -3.8005534078182026e-06 0.018260000000000002 2.4252253853947777e-06 0.018270000000000002 -4.9607018897074997e-06 0.018280000000000001 4.1458347644892417e-06 0.018290000000000001 -2.9366353863246654e-06 0.0183 3.6823614100518296e-06 0.01831 -8.2828653755950112e-06 0.018320000000000003 2.6017431467530072e-06 0.018330000000000003 4.6929932921796802e-08 0.018340000000000002 3.7947705302229349e-06 0.018350000000000002 1.8335291428514108e-06 0.018360000000000001 -3.5843783529707817e-06 0.018370000000000001 -6.5296195235486748e-06 0.018380000000000001 -6.6545489091375944e-06 0.01839 3.4203347592007185e-06 0.018400000000000003 5.6857213638926212e-07 0.018410000000000003 -3.1048580104699178e-06 0.018420000000000002 2.9820690184724109e-06 0.018430000000000002 1.1363945591471882e-05 0.018440000000000002 -2.0194456579086118e-06 0.018450000000000001 -2.0857036517372799e-06 0.018460000000000001 -3.7158521962413947e-06 0.01847 2.9146244594313664e-07 0.01848 -2.2135790164448401e-06 0.018490000000000003 -1.7566908618463336e-06 0.018500000000000003 3.5645662487399647e-06 0.018510000000000002 3.8978846754572665e-06 0.018520000000000002 3.1391959188861313e-06 0.018530000000000001 -1.022538170862877e-05 0.018540000000000001 -7.649987450208407e-06 0.018550000000000001 4.247906453089157e-06 0.01856 2.3652773170104093e-07 0.018570000000000003 3.2160485151769826e-06 0.018580000000000003 -1.1611583675358828e-05 0.018590000000000002 -1.2028041792114594e-07 0.018600000000000002 -9.432200301378679e-07 0.018610000000000002 4.9713203692787067e-06 0.018620000000000001 -3.0923817060129776e-06 0.018630000000000001 1.1993913055743815e-05 0.01864 -9.5370319054246815e-06 0.01865 4.7563338764935637e-06 0.018660000000000003 5.2202687261341845e-06 0.018670000000000003 7.769585937982251e-06 0.018680000000000002 6.2923799468568992e-06 0.018690000000000002 2.9267201760010226e-06 0.018700000000000001 2.3612045547313716e-06 0.018710000000000001 5.2925762137503009e-06 0.018720000000000001 1.5822892451299087e-06 0.01873 5.6015211884971561e-07 0.018740000000000003 -3.4482443178664186e-06 0.018750000000000003 7.2806372036204037e-07 0.018760000000000002 -1.2356981846426827e-06 0.018770000000000002 -4.8773068953209518e-06 0.018780000000000002 8.7472837192953324e-06 0.018790000000000001 -6.2108032532477721e-06 0.018800000000000001 6.9797631749508513e-06 0.01881 -8.9882468558720111e-06 0.01882 -4.8213887525658002e-06 0.018830000000000003 -1.9956434558814053e-06 0.018840000000000003 4.4788903052385765e-06 0.018850000000000002 -9.4835258685913223e-07 0.018860000000000002 2.6995921260676373e-06 0.018870000000000001 -2.50360709476847e-06 0.018880000000000001 -6.2441103685170327e-06 0.018890000000000001 3.2381248597862973e-06 0.0189 -5.8191239789550712e-07 0.018910000000000003 -1.0386988459997151e-06 0.018920000000000003 -6.1760921636892278e-06 0.018930000000000002 5.0988729071383735e-06 0.018940000000000002 -2.0660608397053196e-06 0.018950000000000002 7.7825823526997773e-06 0.018960000000000001 6.3229428956885941e-06 0.018970000000000001 -4.8017564769735293e-06 0.01898 -3.7265242279087627e-06 0.01899 5.8392504807837588e-06 0.019000000000000003 -2.8837677920140983e-06 0.019010000000000003 -5.5280633248886214e-06 0.019020000000000002 6.137300026358851e-06 0.019030000000000002 -3.5062128385193123e-06 0.019040000000000001 8.6994391168838197e-06 0.019050000000000001 -8.9156526262982097e-06 0.019060000000000001 3.6029514576195314e-06 0.01907 1.6352297992451919e-06 0.019080000000000003 -4.2659007091592558e-07 0.019090000000000003 3.282469351462841e-06 0.019100000000000002 -3.7295691154709619e-06 0.019110000000000002 -8.3099019413116082e-06 0.019120000000000002 -4.3705691232216567e-06 0.019130000000000001 9.1074711801912489e-07 0.019140000000000001 -4.4953411758876812e-06 0.01915 -5.6389906101925231e-06 0.01916 2.2751463061738515e-06 0.019170000000000003 -2.7923469229777451e-06 0.019180000000000003 4.7351870628544096e-06 0.019190000000000002 9.944690506402853e-06 0.019200000000000002 1.2911123746252965e-06 0.019210000000000001 -6.0746324003969669e-07 0.019220000000000001 5.5659050701516751e-06 0.019230000000000001 -4.6503803873215986e-06 0.01924 -6.1589443846795361e-06 0.019250000000000003 4.6658749706290593e-06 0.019260000000000003 1.3358131590198468e-06 0.019270000000000002 5.123352918696248e-06 0.019280000000000002 -3.1034811685453228e-07 0.019290000000000002 -5.1225745196559477e-06 0.019300000000000001 -3.6400589365232908e-06 0.019310000000000001 3.8932553145736784e-06 0.01932 5.9694503937955902e-06 0.01933 2.4045500216895484e-06 0.019340000000000003 -8.7203828006758449e-06 0.019350000000000003 -1.611877643609514e-06 0.019360000000000002 -2.7925311768400936e-06 0.019370000000000002 -9.3754059843183763e-07 0.019380000000000001 -4.3986802159183775e-06 0.019390000000000001 -3.9715694458342049e-06 0.019400000000000001 2.7995647390798641e-06 0.01941 6.040970569541413e-06 0.019420000000000003 -2.3106637732771313e-06 0.019430000000000003 -3.6698711494457685e-06 0.019440000000000002 1.3603543043312703e-06 0.019450000000000002 -3.1782564737252479e-06 0.019460000000000002 1.1983286290776439e-06 0.019470000000000001 3.9622107978783207e-06 0.019480000000000001 -6.1737315616264244e-07 0.01949 -5.5428860039406539e-06 0.0195 -6.2542603802230903e-07 0.019510000000000003 -2.5327883132039126e-06 0.019520000000000003 3.3034747727674273e-06 0.019530000000000002 1.0886366340719118e-06 0.019540000000000002 -5.1591407123487266e-06 0.019550000000000001 6.2675209104052404e-06 0.019560000000000001 5.5486243461801839e-06 0.019570000000000001 6.466045036224257e-06 0.01958 1.6914348021447811e-06 0.019590000000000003 -4.0950021555082105e-06 0.019600000000000003 9.3474585098000133e-06 0.019610000000000002 -1.8523251732651459e-06 0.019620000000000002 3.260866105167636e-06 0.019630000000000002 4.3852335878435377e-07 0.019640000000000001 -3.4185732405524079e-06 0.019650000000000001 6.4539736983212309e-06 0.01966 2.2125128856101462e-06 0.01967 -2.347107718418202e-06 0.019680000000000003 6.2664415760307141e-06 0.019690000000000003 -3.2016723931748372e-06 0.019700000000000002 -1.4473543499076996e-06 0.019710000000000002 -4.0668616056704794e-06 0.019720000000000001 -9.2783505790214371e-06 0.019730000000000001 3.6706871877221461e-06 0.019740000000000001 3.0063579256020421e-06 0.01975 -3.759092503534511e-06 0.019760000000000003 5.5804667674671383e-06 0.019770000000000003 8.8871900973301601e-06 0.019780000000000002 -5.8854153337993023e-07 0.019790000000000002 2.6005290205373701e-06 0.019800000000000002 -6.5966696326773882e-06 0.019810000000000001 9.249832439634445e-06 0.019820000000000001 2.4869836774084415e-06 0.01983 4.5406924863648091e-06 0.01984 -3.4299775356018518e-06 0.019850000000000003 5.5204086378336655e-06 0.019860000000000003 1.1489360024460845e-06 0.019870000000000002 -7.4125666408613818e-06 0.019880000000000002 1.7098465230015528e-06 0.019890000000000001 2.099330614284029e-06 0.019900000000000001 -8.9732046023231061e-06 0.019910000000000001 -8.0757296007266868e-06 0.01992 -9.2770312094988807e-06 0.019930000000000003 -5.4205938175634473e-07 0.019940000000000003 -4.1836344139509481e-06 0.019950000000000002 -7.8514696046862123e-06 0.019960000000000002 3.5686466336136974e-08 0.019970000000000002 -1.4939767968891511e-06 0.019980000000000001 4.0747751227566025e-06 0.019990000000000001 -1.1071901980256424e-06 0.02 -1.9427411796304411e-06 0.02001 1.2774180820362803e-06 0.020020000000000003 -3.5613760650240293e-06 0.020030000000000003 5.0498724064664303e-06 0.020040000000000002 -4.8751995847672743e-06 0.020050000000000002 -4.416288508662637e-06 0.020060000000000001 1.0436284235489696e-06 0.020070000000000001 1.2414749602323302e-06 0.020080000000000001 -1.1812522231635191e-05 0.02009 4.0881639338264971e-06 0.020100000000000003 6.5559640863452269e-06 0.020110000000000003 -9.6328158247532513e-06 0.020120000000000002 -3.2750494528473572e-07 0.020130000000000002 -4.2664782047266127e-06 0.020140000000000002 -8.2012189582669449e-06 0.020150000000000001 3.8851125188976671e-06 0.020160000000000001 -2.9642070049520095e-06 0.02017 1.3617052719208269e-06 0.02018 -6.429611613907688e-06 0.020190000000000003 1.1256984851107552e-05 0.020200000000000003 -1.4385547916338658e-06 0.020210000000000002 9.5881569894404492e-08 0.020220000000000002 3.6460990002061457e-06 0.020230000000000001 4.8383119241151003e-06 0.020240000000000001 2.4014499222704166e-06 0.020250000000000001 -5.8396183735632274e-06 0.02026 -4.0982366269961468e-06 0.020270000000000003 4.4835359296140198e-06 0.020280000000000003 2.7535988654261858e-07 0.020290000000000002 3.1242780670026547e-06 0.020300000000000002 -5.7697014579280708e-06 0.020310000000000002 -8.3083029880780159e-06 0.020320000000000001 5.2009455297120489e-06 0.020330000000000001 -1.3383807017653923e-05 0.02034 3.7031912012712446e-06 0.02035 1.7180510811965843e-06 0.020360000000000003 2.9238744713479204e-06 0.020370000000000003 -4.5350830558946557e-06 0.020380000000000002 -1.8999229795387121e-07 0.020390000000000002 -9.3745109359752155e-06 0.020400000000000001 -3.5233661769619522e-06 0.020410000000000001 9.1780567608641474e-06 0.020420000000000001 -1.3957840679792867e-06 0.02043 6.2275068586013868e-06 0.020440000000000003 -9.977530419743856e-06 0.020450000000000003 -8.503307569456357e-06 0.020460000000000002 -8.4112921687952841e-06 0.020470000000000002 1.1465685587586138e-07 0.020480000000000002 3.5332114905499123e-06 0.020490000000000001 1.5811172929141383e-06 0.020500000000000001 5.9113059881933884e-06 0.02051 2.6844781801822416e-06 0.02052 5.6192821358540792e-06 0.020530000000000003 6.5396347647490445e-07 0.020540000000000003 -1.2735846642328881e-06 0.020550000000000002 -7.0527952462800439e-06 0.020560000000000002 -4.5222489252570364e-06 0.020570000000000001 1.0829140950763382e-06 0.020580000000000001 -8.5740616666102994e-06 0.020590000000000001 7.532633903896722e-06 0.0206 4.2642566095937782e-06 0.020610000000000003 7.5041007793084685e-06 0.020620000000000003 5.1762453993772208e-06 0.020630000000000003 1.3143128596019264e-06 0.020640000000000002 8.490073334698157e-06 0.020650000000000002 1.1785936759929175e-06 0.020660000000000001 -1.1793367726535207e-05 0.020670000000000001 -1.1447571319740121e-05 0.02068 6.4206877992875081e-06 0.02069 -8.6098776259988432e-06 0.020700000000000003 -3.5427121629660684e-06 0.020710000000000003 7.8610047027034781e-07 0.020720000000000002 5.4939104935218789e-06 0.020730000000000002 2.4979399039315815e-06 0.020740000000000001 -1.0130604126687828e-05 0.020750000000000001 1.4162991289805966e-06 0.020760000000000001 2.7048072769510702e-06 0.02077 1.9971155022462571e-06 0.020780000000000003 -2.3871673438455337e-06 0.020790000000000003 -1.6990759307437859e-07 0.020800000000000003 2.5231430687714954e-07 0.020810000000000002 6.5114299042940611e-06 0.020820000000000002 1.5047725007744981e-06 0.020830000000000001 1.1967828124075779e-06 0.020840000000000001 -1.489393524662393e-06 0.02085 -6.7072147955329196e-06 0.02086 -4.9106831288092272e-07 0.020870000000000003 -5.5840502585580348e-06 0.020880000000000003 2.50932772908548e-06 0.020890000000000002 -5.495660904340693e-06 0.020900000000000002 1.1014008925494639e-05 0.020910000000000002 4.2024837802902443e-06 0.020920000000000001 -1.6638916809664495e-06 0.020930000000000001 3.0078326431349312e-06 0.02094 -6.0485422088208346e-06 0.020950000000000003 -1.0504003374723045e-06 0.020960000000000003 -3.120487971362127e-06 0.020970000000000003 -5.099870373921599e-06 0.020980000000000002 6.5857496043835008e-07 0.020990000000000002 -4.6144832894279357e-06 0.021000000000000001 5.4984370939841789e-06 0.021010000000000001 7.4053641588014241e-07 0.02102 1.3639390277237056e-08 0.02103 -5.0007037221040809e-06 0.021040000000000003 1.4588435825245186e-08 0.021050000000000003 -5.2060732266333554e-06 0.021060000000000002 2.2424732012530555e-06 0.021070000000000002 -2.6774169756718198e-06 0.021080000000000002 -1.1219961495751566e-05 0.021090000000000001 1.4220207659201458e-06 0.021100000000000001 6.9413467890040286e-07 0.02111 -1.0851792402686803e-05 0.021120000000000003 2.3672600148456945e-07 0.021130000000000003 -6.4824158451374342e-06 0.021140000000000003 -2.0447159513435748e-06 0.021150000000000002 1.4591767580390919e-07 0.021160000000000002 2.9808254032378203e-07 0.021170000000000001 1.0829469426713539e-06 0.021180000000000001 4.2031601742570616e-07 0.021190000000000001 6.1906348985038879e-06 0.0212 -1.4967103558948496e-06 0.021210000000000003 -1.0106064432904924e-06 0.021220000000000003 2.9175613816042596e-07 0.021230000000000002 7.7108894662212974e-06 0.021240000000000002 1.1513597122557781e-05 0.021250000000000002 3.9094886813450087e-06 0.021260000000000001 8.9725430365062063e-07 0.021270000000000001 7.1134979204911328e-09 0.02128 -1.2088690436909771e-06 0.021290000000000003 -6.945451963452907e-06 0.021300000000000003 2.8181934587888974e-06 0.021310000000000003 2.5444227555856913e-06 0.021320000000000002 5.7790978750177058e-06 0.021330000000000002 4.8710317371313349e-06 0.021340000000000001 3.2018445660506442e-06 0.021350000000000001 1.103530098711902e-06 0.021360000000000001 2.3525002376235846e-06 0.02137 3.70074050503242e-06 0.021380000000000003 -4.696080228764657e-06 0.021390000000000003 -2.1985197575072565e-06 0.021400000000000002 1.6323724383732582e-06 0.021410000000000002 -8.7866407738403027e-06 0.021420000000000002 4.4727405507166571e-06 0.021430000000000001 8.8366447787477952e-06 0.021440000000000001 -1.0277911156490208e-06 0.02145 -5.3753323009627392e-06 0.021460000000000003 4.20657452304823e-07 0.021470000000000003 4.8088483320194149e-06 0.021480000000000003 -1.7541301591309673e-06 0.021490000000000002 -5.0849695942007325e-06 0.021500000000000002 -6.239778028747678e-06 0.021510000000000001 -1.0833269023496211e-06 0.021520000000000001 1.0011324974288808e-05 0.021530000000000001 -2.3613147730523149e-07 0.02154 -4.8554962758535446e-06 0.021550000000000003 5.0992771537999575e-06 0.021560000000000003 -1.0820792643415579e-05 0.021570000000000002 -7.6635273942800821e-06 0.021580000000000002 1.9913081173176026e-06 0.021590000000000002 -1.5784686676792837e-06 0.021600000000000001 -2.0162173394220928e-06 0.021610000000000001 -1.0478708649950685e-05 0.02162 -2.0157032504759454e-06 0.021630000000000003 3.1573017302359287e-06 0.021640000000000003 -3.284357695373596e-06 0.021650000000000003 5.858977412644155e-06 0.021660000000000002 1.6346608192190057e-06 0.021670000000000002 -2.536789532709364e-06 0.021680000000000001 -9.7918737311014067e-07 0.021690000000000001 1.0188427771883968e-05 0.021700000000000001 9.715907125238438e-06 0.02171 -3.6071954628046104e-06 0.021720000000000003 4.6605450697856006e-06 0.021730000000000003 -7.1903644294382356e-06 0.021740000000000002 -1.0803437315533805e-05 0.021750000000000002 1.9278011313526439e-06 0.021760000000000002 3.7333794380157839e-06 0.021770000000000001 3.6951043129793572e-06 0.021780000000000001 -1.6213000173934585e-06 0.02179 -3.9056067815644918e-06 0.021800000000000003 -2.2022610965222809e-06 0.021810000000000003 2.5229991238538843e-06 0.021820000000000003 7.6946126834521423e-06 0.021830000000000002 -8.8856017518715039e-06 0.021840000000000002 -1.2835821038373078e-06 0.021850000000000001 -9.9413113019378851e-06 0.021860000000000001 1.8523397128126084e-06 0.021870000000000001 -5.8419663464987574e-06 0.02188 7.6300201360203703e-06 0.021890000000000003 -4.7904750949661628e-06 0.021900000000000003 -1.8004239999309139e-06 0.021910000000000002 2.3792015899003695e-06 0.021920000000000002 -6.6609986337586017e-06 0.021930000000000002 -5.129441867725386e-07 0.021940000000000001 7.4256400780054206e-06 0.021950000000000001 -2.3099801128262876e-06 0.02196 -1.3636559779418543e-06 0.021970000000000003 -1.0044872084067296e-05 0.021980000000000003 9.8676504678588469e-06 0.021990000000000003 8.17765717499759e-06 0.022000000000000002 -2.9345109394835936e-06 0.022010000000000002 -8.6890506794776392e-06 0.022020000000000001 1.3119297819241247e-05 0.022030000000000001 -2.4287632693953099e-06 0.022040000000000001 -5.1872422539948833e-06 0.02205 3.5065327999351361e-06 0.022060000000000003 3.7039841922441249e-06 0.022070000000000003 -8.0283623723256295e-06 0.022080000000000002 -5.7304979222783963e-06 0.022090000000000002 2.0122659868964254e-06 0.022100000000000002 1.4574267852193255e-05 0.022110000000000001 -2.967903425656473e-06 0.022120000000000001 -3.58452091007064e-06 0.02213 -2.931923735727803e-06 0.022140000000000003 -6.0691807338892691e-06 0.022150000000000003 1.5495409261410619e-05 0.022160000000000003 7.7031562081866113e-06 0.022170000000000002 2.1568320589835046e-06 0.022180000000000002 3.6536177104602317e-06 0.022190000000000001 8.1730770799966631e-06 0.022200000000000001 9.3519965399129463e-06 0.022210000000000001 -4.6785084537251994e-06 0.02222 2.7096974750493226e-06 0.022230000000000003 -5.5537358955835305e-06 0.022240000000000003 2.2493978813925966e-06 0.022250000000000002 -3.2972779481834993e-06 0.022260000000000002 4.7126784199203864e-06 0.022270000000000002 1.9119538973518054e-06 0.022280000000000001 3.0103705493703188e-06 0.022290000000000001 2.456840293918281e-06 0.0223 -3.2930224113949748e-07 0.022310000000000003 -1.4354485125800544e-05 0.022320000000000003 -1.5398693422466386e-07 0.022330000000000003 2.7063857682014681e-06 0.022340000000000002 1.3573800724289839e-05 0.022350000000000002 -9.9344377462651548e-06 0.022360000000000001 -1.0576699190821487e-05 0.022370000000000001 6.1515030488050357e-06 0.022380000000000001 3.7656146350241758e-06 0.02239 6.4540641968094551e-06 0.022400000000000003 -5.177587275895561e-06 0.022410000000000003 -5.9361365532620361e-07 0.022420000000000002 2.7888085695999767e-06 0.022430000000000002 2.5407364538848657e-06 0.022440000000000002 8.242814976494908e-06 0.022450000000000001 6.4780123875004116e-06 0.022460000000000001 -3.1632544855733776e-06 0.02247 -1.309454666524641e-06 0.022480000000000003 -7.7493822055293647e-06 0.022490000000000003 3.1617631563855649e-06 0.022500000000000003 5.4488935788613527e-06 0.022510000000000002 -2.0434421751590215e-06 0.022520000000000002 -3.7444644926734037e-06 0.022530000000000001 -3.9955427815042178e-07 0.022540000000000001 -4.148504831239377e-06 0.022550000000000001 2.0151824126556568e-06 0.02256 -3.9068787921907806e-06 0.022570000000000003 -1.3125797775163747e-06 0.022580000000000003 9.2608509032319234e-07 0.022590000000000002 3.0664491610545522e-06 0.022600000000000002 -1.2515786984314109e-05 0.022610000000000002 -1.3166106325607224e-07 0.022620000000000001 -3.1950079805243101e-06 0.022630000000000001 2.5272236933649662e-06 0.02264 3.0300854839788829e-06 0.022650000000000003 -1.1400183758047706e-06 0.022660000000000003 -5.0379868879370262e-06 0.022670000000000003 5.7534878484202385e-06 0.022680000000000002 3.7576670652083378e-06 0.022690000000000002 3.2588121515983146e-06 0.022700000000000001 1.0623384697999713e-05 0.022710000000000001 6.7582519597093529e-06 0.022720000000000001 1.8585509352206812e-06 0.02273 -1.1323433963238549e-05 0.022740000000000003 -6.4753018771082978e-06 0.022750000000000003 -1.324435887036581e-05 0.022760000000000002 -6.040652273893058e-07 0.022770000000000002 -7.5361258811511517e-07 0.022780000000000002 -2.6284748066653141e-06 0.022790000000000001 -6.3304302836701549e-07 0.022800000000000001 -7.2920614807389804e-06 0.02281 -7.8769514483141122e-06 0.022820000000000003 9.0603056372677608e-07 0.022830000000000003 -3.1110877021129639e-06 0.022840000000000003 -1.2439580347047236e-05 0.022850000000000002 -2.7794004985267477e-06 0.022860000000000002 -3.8649760460175499e-07 0.022870000000000001 1.095862698698144e-06 0.022880000000000001 8.7008857123117088e-06 0.022890000000000001 9.7276514864620972e-07 0.0229 -1.5218291805135255e-06 0.022910000000000003 -3.9091298399752565e-08 0.022920000000000003 -5.9022848633875109e-06 0.022930000000000002 6.2613169598108645e-06 0.022940000000000002 -8.2200610178534465e-06 0.022950000000000002 3.1597029025746874e-06 0.022960000000000001 -1.6992023265146599e-06 0.022970000000000001 -4.3498216154793677e-06 0.02298 -6.0075714612039295e-06 0.022990000000000003 1.513951432082764e-05 0.023000000000000003 2.9996547151617939e-06 0.023010000000000003 4.9375848118070081e-06 0.023020000000000002 -8.7536709377115344e-06 0.023030000000000002 7.8355920069891837e-06 0.023040000000000001 -1.4298839232413916e-06 0.023050000000000001 -3.658869714092149e-06 0.023060000000000001 -1.7404188169841298e-06 0.02307 -2.9030304476583545e-07 0.023080000000000003 -1.865374216159957e-07 0.023090000000000003 -1.7228368213690841e-06 0.023100000000000002 2.4183963104907077e-06 0.023110000000000002 -4.8808351525007629e-06 0.023120000000000002 -4.1046628375711836e-06 0.023130000000000001 1.3919941319730058e-06 0.023140000000000001 -4.1216000267655877e-06 0.02315 -3.445251580834222e-06 0.023160000000000004 -3.0033427802498695e-06 0.023170000000000003 -7.1179745360207941e-06 0.023180000000000003 3.6684813087262994e-07 0.023190000000000002 2.2879000033236519e-07 0.023200000000000002 4.2431417951094546e-06 0.023210000000000001 2.3874772998354146e-06 0.023220000000000001 3.7868946109412576e-06 0.023230000000000001 -1.0710644202476537e-06 0.02324 4.7120494779226929e-07 0.023250000000000003 -1.7111853804286111e-05 0.023260000000000003 -3.2000350675911338e-06 0.023270000000000002 -6.7283294773191439e-06 0.023280000000000002 1.61142766183216e-05 0.023290000000000002 2.0492966748221514e-06 0.023300000000000001 -5.3411322481544747e-06 0.023310000000000001 1.852048348678328e-06 0.02332 3.4548695078141047e-06 0.023330000000000004 5.5223024371402931e-06 0.023340000000000003 5.5250747223457066e-06 0.023350000000000003 -2.709040971114924e-06 0.023360000000000002 -6.0266547316695309e-06 0.023370000000000002 5.5494978683037535e-07 0.023380000000000001 7.2967085742951996e-07 0.023390000000000001 -1.5988375219660041e-06 0.023400000000000001 -1.0565867322344769e-05 0.02341 -9.7539970075084937e-07 0.023420000000000003 1.1308836124408636e-06 0.023430000000000003 3.9392156547102038e-06 0.023440000000000003 -1.0216991200849202e-06 0.023450000000000002 -6.1541287284772447e-06 0.023460000000000002 4.1729649737775165e-06 0.023470000000000001 4.8889294225490901e-06 0.023480000000000001 -6.4146383457007341e-07 0.02349 3.6320126748013656e-07 0.023500000000000004 -5.0301689072341128e-06 0.023510000000000003 7.1061067647464673e-06 0.023520000000000003 1.0973716513343127e-05 0.023530000000000002 7.9344438669282036e-06 0.023540000000000002 -7.8992326273519977e-06 0.023550000000000001 -2.5414646373564701e-06 0.023560000000000001 4.2332593444386043e-06 0.023570000000000001 -3.5100298173164112e-06 0.02358 2.143045654593684e-06 0.023590000000000003 1.4286499901514724e-06 0.023600000000000003 2.2040110505598791e-06 0.023610000000000003 6.1121198599248071e-07 0.023620000000000002 1.8154493387758623e-06 0.023630000000000002 1.73877734077785e-07 0.023640000000000001 -4.9948889114472615e-07 0.023650000000000001 3.3316992471922364e-06 0.02366 5.9521682611826638e-06 0.023670000000000004 -6.3284576915926079e-08 0.023680000000000003 -1.1052901173326862e-06 0.023690000000000003 -2.3150189441459234e-07 0.023700000000000002 1.9759884271858154e-07 0.023710000000000002 1.4961287790535423e-06 0.023720000000000001 6.6360054295258558e-07 0.023730000000000001 -1.1380109662529968e-05 0.023740000000000001 5.6473837060862317e-06 0.02375 9.4687270810470268e-07 0.023760000000000003 8.1293381979519971e-06 0.023770000000000003 3.0866646919684186e-06 0.023780000000000003 -5.0488470726331473e-06 0.023790000000000002 -1.7781559512234856e-07 0.023800000000000002 4.8360467108688603e-06 0.023810000000000001 3.1414468491787626e-06 0.023820000000000001 -6.1296428094657151e-07 0.02383 -1.423245014343456e-05 0.023840000000000004 -2.4827102479276921e-06 0.023850000000000003 1.1419187100011095e-06 0.023860000000000003 -1.6228379384072502e-06 0.023870000000000002 3.2498959886285995e-06 0.023880000000000002 -1.0223111312655325e-06 0.023890000000000002 -3.9222982893624807e-06 0.023900000000000001 -9.0445303984552234e-06 0.023910000000000001 2.8659946694106756e-08 0.02392 3.9795309753838618e-06 0.023930000000000003 2.8390224236965821e-06 0.023940000000000003 1.40820772081844e-06 0.023950000000000003 -6.1633292554842793e-07 0.023960000000000002 -6.3038530072641786e-07 0.023970000000000002 -6.3203977920085213e-06 0.023980000000000001 1.3214787274599827e-06 0.023990000000000001 -1.4265055898261803e-06 0.024 4.3992879028281276e-07)
Vtargetnoise targetnoise 0 PWL(0 1.1466183602490275e-05 1.0000000000000001e-05 -6.034469885853735e-06 2.0000000000000002e-05 -1.4071294566377857e-06 3.0000000000000004e-05 9.4732329174587142e-06 4.0000000000000003e-05 -7.6365467245556523e-07 5.0000000000000002e-05 -2.5052001837943442e-06 6.0000000000000008e-05 1.0877724991946146e-05 7.0000000000000007e-05 -1.047138400155701e-06 8.0000000000000007e-05 3.0740453698358126e-06 9.0000000000000006e-05 3.9933431787443218e-06 0.0001 7.7992779695846696e-06 0.00011 -3.6606692618945245e-06 0.00012000000000000002 3.2222510998231621e-06 0.00013000000000000002 3.0137023052150806e-06 0.00014000000000000001 6.8063571457021162e-06 0.00015000000000000001 -4.1263027785527783e-06 0.00016000000000000001 -2.0366063531952044e-06 0.00017000000000000001 -2.9600535876884346e-06 0.00018000000000000001 -3.9481818389284651e-06 0.00019000000000000001 4.1379775596935544e-06 0.00020000000000000001 2.6093198465588837e-06 0.00021000000000000001 2.924064578754792e-06 0.00022000000000000001 1.3721298853482524e-06 0.00023000000000000001 5.478328946544216e-08 0.00024000000000000003 -1.0787744971474562e-06 0.00025000000000000001 -4.179681319686314e-06 0.00026000000000000003 8.2408681147692934e-06 0.00027 5.6738446899683996e-06 0.00028000000000000003 -6.5864566049962929e-06 0.00029 -6.9398141460942683e-06 0.00030000000000000003 -7.2906638142248971e-06 0.00031 6.3523527016659473e-06 0.00032000000000000003 9.533989546019002e-06 0.00033000000000000005 4.5193709371350503e-06 0.00034000000000000002 1.8799356751909408e-06 0.00035000000000000005 -6.1264185202746155e-06 0.00036000000000000002 2.245185637376809e-06 0.00037000000000000005 -9.1999163299112559e-06 0.00038000000000000002 -9.4644895219648639e-06 0.00039000000000000005 -1.1803354473185381e-05 0.00040000000000000002 8.063548150728613e-06 0.00041000000000000005 -2.2290265941086407e-06 0.00042000000000000002 -5.0205125187636751e-06 0.00043000000000000004 -1.2392795721252441e-06 0.00044000000000000002 5.7371386308640721e-07 0.00045000000000000004 7.9513765276242149e-06 0.00046000000000000001 -6.5062216903058341e-06 0.00047000000000000004 2.9766225478821765e-06 0.00048000000000000007 8.9907811063744608e-07 0.00049000000000000009 -2.0247597420647124e-06 0.00050000000000000001 -5.3812287577775147e-06 0.00051000000000000004 4.3937973166918499e-06 0.00052000000000000006 -1.5812847609513746e-05 0.00053000000000000009 -3.7381708859269922e-06 0.00054000000000000001 2.3371946692943078e-06 0.00055000000000000003 -2.427646026681868e-06 0.00056000000000000006 -9.1811437509260833e-07 0.00057000000000000009 -3.533099450030223e-06 0.00058 1.5685720104222974e-06 0.00059000000000000003 -3.8564960777018747e-06 0.00060000000000000006 -6.4215804952998197e-06 0.00061000000000000008 1.0071166604684364e-05 0.00062 -3.0545743429616694e-06 0.00063000000000000003 -9.2052471005222311e-06 0.00064000000000000005 7.9854208645987516e-06 0.00065000000000000008 5.8778122261968682e-06 0.0006600000000000001 4.7094800804784043e-06 0.00067000000000000002 -2.4466874914754492e-06 0.00068000000000000005 -8.2812910925411229e-06 0.00069000000000000008 -6.5687142979114087e-07 0.0007000000000000001 2.351387415546021e-06 0.00071000000000000002 4.7854537838468465e-06 0.00072000000000000005 -1.5262566969442048e-07 0.00073000000000000007 -1.1651211155936226e-05 0.0007400000000000001 2.3400429433859985e-06 0.00075000000000000002 -7.0125467973852262e-07 0.00076000000000000004 6.1545673622296305e-07 0.00077000000000000007 2.4222887583999381e-08 0.00078000000000000009 3.9298404692835318e-06 0.00079000000000000001 6.2900606538304036e-06 0.00080000000000000004 8.2476557365047353e-06 0.00081000000000000006 3.5606507283039214e-06 0.00082000000000000009 5.8836333742785926e-06 0.00083000000000000012 1.9043896351560837e-06 0.00084000000000000003 3.2201894529454115e-06 0.00085000000000000006 -1.8656205824138034e-06 0.00086000000000000009 4.4130297662271646e-06 0.00087000000000000011 7.2441733124039693e-06 0.00088000000000000003 -3.0831613264906452e-06 0.00089000000000000006 2.7522385915912171e-06 0.00090000000000000008 3.5098531809039384e-06 0.00091000000000000011 -4.5077705719484934e-06 0.00092000000000000003 -5.1812753018925552e-07 0.00093000000000000005 -6.1312489999969428e-06 0.00094000000000000008 3.5859937376482624e-06 0.00095000000000000011 -4.1713443981502625e-06 0.00096000000000000013 -2.4498694641929361e-06 0.00097000000000000005 -2.779924780100572e-06 0.00098000000000000019 -1.132998143973708e-05 0.00098999999999999999 -8.6270366813438663e-07 0.001 -2.0322075924323923e-06 0.00101 5.4463819480668819e-06 0.0010200000000000001 1.9398983736952901e-06 0.0010300000000000001 -1.2621881976028092e-06 0.0010400000000000001 -6.0317520783651752e-07 0.0010500000000000002 1.1021797841887973e-05 0.0010600000000000002 2.3085197468871987e-06 0.00107 4.9127859296041123e-06 0.00108 -1.1322690015344948e-06 0.00109 6.9234398287205647e-06 0.0011000000000000001 -9.2474367779696508e-06 0.0011100000000000001 2.0081837353210633e-07 0.0011200000000000001 -9.7783040693833793e-06 0.0011300000000000001 -3.0527128649052301e-06 0.0011400000000000002 -3.3500227598055692e-06 0.0011500000000000002 -3.2945555918187172e-06 0.00116 3.542287395994919e-06 0.00117 -5.4592682888555682e-06 0.0011800000000000001 4.2911937467321512e-06 0.0011900000000000001 2.959142567628363e-06 0.0012000000000000001 2.9262600606096009e-06 0.0012100000000000001 5.3685122123234448e-06 0.0012200000000000002 8.6177332869380766e-06 0.0012300000000000002 6.1739753173683194e-06 0.00124 -4.6828518291247859e-06 0.00125 4.135305835956324e-06 0.0012600000000000001 4.0792100096434334e-06 0.0012700000000000001 -2.4333088000614779e-06 0.0012800000000000001 -7.2108309709723819e-06 0.0012900000000000001 4.1313739386354543e-06 0.0013000000000000002 3.8120202258414147e-06 0.0013100000000000002 -3.0812336495628375e-06 0.0013200000000000002 -5.1987828346228761e-06 0.00133 8.8916528824000917e-06 0.00134 -3.304457522490655e-06 0.0013500000000000001 7.4528300763933505e-06 0.0013600000000000001 -4.2085391801726531e-06 0.0013700000000000001 -3.6807635138146285e-06 0.0013800000000000002 8.181625475183211e-07 0.0013900000000000002 -4.5716963673552429e-06 0.0014000000000000002 -2.9950787569224569e-06 0.00141 -9.8967576696986606e-07 0.00142 6.6008710785294192e-07 0.0014300000000000001 -1.5063388050983915e-06 0.0014400000000000001 -3.8957572663318021e-06 0.0014500000000000001 -3.1044702019358091e-06 0.0014600000000000001 2.2076239032570176e-06 0.0014700000000000002 3.2518306763983997e-06 0.0014800000000000002 -8.2270275648013472e-06 0.0014900000000000002 3.0054249063563374e-06 0.0015 -3.4264311444673786e-06 0.0015100000000000001 2.8100422394675459e-06 0.0015200000000000001 -3.0196244544540891e-06 0.0015300000000000001 -3.1558356174549617e-07 0.0015400000000000001 -3.2129852373469105e-06 0.0015500000000000002 -1.4113665687241662e-05 0.0015600000000000002 5.3863874070702988e-07 0.0015700000000000002 -1.5329515192634452e-06 0.00158 7.4808947944544546e-07 0.0015900000000000001 7.3709501755308902e-06 0.0016000000000000001 -6.9695593925919431e-07 0.0016100000000000001 -4.8705847986991534e-06 0.0016200000000000001 9.8106454938983728e-06 0.0016300000000000002 3.2214928993829853e-06 0.0016400000000000002 -3.5967354250686621e-06 0.0016500000000000002 -9.7184831094069128e-06 0.0016600000000000002 2.0400979876726655e-06 0.00167 -7.1173183501184358e-06 0.0016800000000000001 1.5601196951473796e-06 0.0016900000000000001 -4.9817387156731532e-06 0.0017000000000000001 -3.2355565497887404e-06 0.0017100000000000001 1.909150606588037e-06 0.0017200000000000002 -2.7882811661074429e-06 0.0017300000000000002 -5.4319308049288842e-06 0.0017400000000000002 3.9482028532071951e-06 0.00175 9.0124135388828623e-07 0.0017600000000000001 5.9951455177920633e-06 0.0017700000000000001 -4.8783117051695491e-07 0.0017800000000000001 1.0564831843743788e-06 0.0017900000000000001 -4.4450023994047222e-06 0.0018000000000000002 2.15700050264971e-06 0.0018100000000000002 1.495567549183295e-06 0.0018200000000000002 -3.0511409975132209e-06 0.0018300000000000002 -3.3164478317250544e-06 0.0018400000000000001 -4.8297886763382795e-06 0.0018500000000000001 1.7228508084584652e-06 0.0018600000000000001 2.3387199464271044e-06 0.0018700000000000001 -2.6815044068853262e-06 0.0018800000000000002 -2.9268171545786014e-07 0.0018900000000000002 -5.5178572696753216e-06 0.0019000000000000002 3.5313820379480312e-06 0.0019100000000000002 -6.0012746048444751e-06 0.0019200000000000003 5.5161450607901731e-07 0.0019300000000000001 1.5689814042892169e-06 0.0019400000000000001 6.8023695614527792e-06 0.0019500000000000001 3.2312558429483055e-06 0.0019600000000000004 1.2210441806401221e-06 0.00197 1.3139704309172144e-06 0.00198 -6.2231790536380497e-06 0.00199 4.2884100187220965e-06 0.002 -4.2717362307797985e-06 0.0020100000000000001 -6.7568002793580604e-06 0.0020200000000000001 -3.7562052083677101e-06 0.0020300000000000001 -1.156373458667078e-06 0.0020400000000000001 4.2986925995318071e-06 0.0020500000000000002 -2.623273949035766e-07 0.0020600000000000002 -3.371390616298817e-06 0.0020700000000000002 7.6265049127038223e-06 0.0020800000000000003 -7.8694434593984432e-06 0.0020900000000000003 5.436169753536085e-06 0.0021000000000000003 -6.3153471394436237e-07 0.0021100000000000003 9.0263708455581969e-06 0.0021200000000000004 -1.1143021859945928e-05 0.0021300000000000004 -1.8281419604100996e-06 0.00214 -5.1205289642964079e-07 0.00215 -1.1429227412261763e-05 0.00216 1.8797302644937872e-06 0.0021700000000000001 -3.9926138932405023e-06 0.0021800000000000001 2.974985994233525e-06 0.0021900000000000001 2.7458405403048579e-06 0.0022000000000000001 5.3788466664306059e-06 0.0022100000000000002 1.5592523200258028e-07 0.0022200000000000002 -1.0518170232731952e-05 0.0022300000000000002 1.0645479699488325e-07 0.0022400000000000002 2.842801089029022e-06 0.0022500000000000003 -3.6966971389672435e-06 0.0022600000000000003 -4.6519247217690988e-06 0.0022700000000000003 4.7936346742112768e-07 0.0022800000000000003 3.7776438365408634e-06 0.0022900000000000004 -3.6980193459032228e-06 0.0023000000000000004 -4.5317219473727295e-06 0.00231 -6.5764453315746302e-06 0.00232 -2.0358589737816983e-06 0.00233 -7.3849025776638076e-06 0.0023400000000000001 -3.9433039375944284e-06 0.0023500000000000001 -9.4180897260718554e-06 0.0023600000000000001 -8.5059577540840361e-06 0.0023700000000000001 3.2083766603868273e-06 0.0023800000000000002 -3.3249626139026573e-06 0.0023900000000000002 -3.4493600309540632e-06 0.0024000000000000002 2.6241912695274434e-06 0.0024100000000000002 -4.4629692455634019e-06 0.0024200000000000003 4.9618897879444825e-09 0.0024300000000000003 2.8765111215290796e-06 0.0024400000000000003 -4.914656586853763e-07 0.0024500000000000004 -6.9276557696107469e-06 0.0024600000000000004 -6.2021797818666224e-07 0.0024700000000000004 -5.9628349443592034e-06 0.00248 1.2836012579131146e-05 0.00249 -3.6594860979337743e-07 0.0025000000000000001 -1.1276667275448971e-06 0.0025100000000000001 -7.9209611249850519e-06 0.0025200000000000001 6.1992397264802596e-07 0.0025300000000000001 -2.8198624177854666e-06 0.0025400000000000002 -5.2871838261052578e-06 0.0025500000000000002 2.4597173420957259e-07 0.0025600000000000002 -9.9951013101639319e-07 0.0025700000000000002 1.5461829131508249e-05 0.0025800000000000003 4.5683395659406894e-07 0.0025900000000000003 -5.4131489057563536e-07 0.0026000000000000003 4.3433541336083375e-06 0.0026100000000000003 -7.4512241941893019e-06 0.0026200000000000004 -7.7440863661837672e-06 0.0026300000000000004 -4.4785974475306343e-06 0.0026400000000000004 5.3148437964371533e-06 0.00265 -3.6062117217471863e-06 0.00266 -1.4730998456795547e-05 0.0026700000000000001 -8.8512303641543147e-07 0.0026800000000000001 1.1795030010243163e-06 0.0026900000000000001 -4.2932258387945861e-06 0.0027000000000000001 -1.7324949836280161e-06 0.0027100000000000002 5.990718444828659e-07 0.0027200000000000002 -3.3762683225329263e-06 0.0027300000000000002 1.0933795287861906e-05 0.0027400000000000002 7.1558219297883026e-06 0.0027500000000000003 -1.1470698721999089e-06 0.0027600000000000003 -1.0776644149926182e-06 0.0027700000000000003 8.279252622242381e-07 0.0027800000000000004 1.1012903690752204e-06 0.0027900000000000004 -1.6629232117083328e-06 0.0028000000000000004 -2.1336533903497316e-06 0.0028100000000000004 1.0753435443972741e-05 0.00282 1.0056876874848572e-05 0.0028300000000000001 -1.2179357594202232e-06 0.0028400000000000001 1.1065612210100198e-05 0.0028500000000000001 -2.4468658265709804e-06 0.0028600000000000001 -6.6496898265275713e-06 0.0028700000000000002 2.5199043807910924e-06 0.0028800000000000002 -1.6819620669152292e-06 0.0028900000000000002 -6.3213740461780406e-06 0.0029000000000000002 -2.4826964830260581e-06 0.0029100000000000003 2.9060957922998031e-06 0.0029200000000000003 2.0439714745019651e-07 0.0029300000000000003 8.5965813410243388e-07 0.0029400000000000003 1.4653710719830175e-06 0.0029500000000000004 -1.8406505473401761e-06 0.0029600000000000004 -4.1320547823618265e-06 0.0029700000000000004 -3.789775312660628e-06 0.0029800000000000004 1.0838765579051069e-06 0.00299 2.6980283972157645e-06 0.0030000000000000001 -3.2083213561634081e-06 0.0030100000000000001 -8.5753830819509385e-06 0.0030200000000000001 1.4065963454688939e-06 0.0030300000000000001 -2.3726416037321111e-06 0.0030400000000000002 2.5711661447373914e-06 0.0030500000000000002 -3.8709688196782095e-06 0.0030600000000000002 7.6876168334648473e-07 0.0030700000000000002 2.2828536981682179e-06 0.0030800000000000003 -2.1702249325811665e-06 0.0030900000000000003 -5.3930640620870915e-07 0.0031000000000000003 -1.6202060109003337e-06 0.0031100000000000004 7.3318106267790211e-07 0.0031200000000000004 -4.6830110695990608e-06 0.0031300000000000004 -8.7705278433126776e-06 0.0031400000000000004 -7.122840112454771e-07 0.0031500000000000005 -2.6495784010664708e-06 0.00316 3.5632358492454629e-06 0.0031700000000000001 -2.3464925360068795e-06 0.0031800000000000001 -2.9879477830631205e-06 0.0031900000000000001 5.1978668182007116e-06 0.0032000000000000002 -3.353304745392393e-06 0.0032100000000000002 5.8045944481514114e-08 0.0032200000000000002 3.3178301912231307e-06 0.0032300000000000002 7.3734360011016847e-06 0.0032400000000000003 -1.1954275474805501e-07 0.0032500000000000003 4.2675526499460952e-06 0.0032600000000000003 -1.9295906676030064e-06 0.0032700000000000003 8.1441228139518949e-06 0.0032800000000000004 -1.0177563084491353e-06 0.0032900000000000004 4.9256559226466903e-06 0.0033000000000000004 -3.4049664747291981e-06 0.0033100000000000004 1.1955363781953026e-06 0.0033200000000000005 8.0098425107793379e-07 0.0033300000000000001 -5.3595973609550549e-07 0.0033400000000000001 -1.3295353468977799e-07 0.0033500000000000001 -2.3002582369991316e-06 0.0033600000000000001 -6.7099436652270931e-06 0.0033700000000000002 -8.4412249637446751e-07 0.0033800000000000002 -5.6461637589753503e-06 0.0033900000000000002 7.0822015147753451e-06 0.0034000000000000002 -6.6492561867591542e-06 0.0034100000000000003 7.0166246768750164e-06 0.0034200000000000003 2.9588191722855365e-06 0.0034300000000000003 3.0961887512176481e-06 0.0034400000000000003 5.9186051330258983e-06 0.0034500000000000004 5.6471544244499233e-06 0.0034600000000000004 -2.7883180225356094e-07 0.0034700000000000004 -4.3916659024634033e-06 0.0034800000000000005 3.1433041802632265e-06 0.0034900000000000005 -5.3525166494991613e-06 0.0035000000000000001 1.517217004600495e-06 0.0035100000000000001 5.6033699713666721e-06 0.0035200000000000001 -5.3649639049649338e-06 0.0035300000000000002 5.0580665870519705e-06 0.0035400000000000002 3.4226315984901031e-07 0.0035500000000000002 1.1289588338982819e-05 0.0035600000000000002 -6.7882124816142415e-06 0.0035700000000000003 -8.2771697527973787e-06 0.0035800000000000003 6.1867405737989817e-06 0.0035900000000000003 9.0538918120229497e-06 0.0036000000000000003 -8.6248458705975315e-06 0.0036100000000000004 8.4874716276683619e-07 0.0036200000000000004 9.56816089542243e-06 0.0036300000000000004 2.8959932902138003e-06 0.0036400000000000004 6.2309503730140197e-06 0.0036500000000000005 1.284132972796841e-06 0.0036600000000000005 3.0307163163168686e-06 0.0036700000000000001 -2.6448318796386745e-06 0.0036800000000000001 2.5180775988298885e-06 0.0036900000000000001 -1.7013028504716852e-06 0.0037000000000000002 -7.5905863561448366e-06 0.0037100000000000002 1.0840172441333878e-06 0.0037200000000000002 4.8213062453606205e-06 0.0037300000000000002 -5.9300436101473193e-07 0.0037400000000000003 -4.1416974416631675e-06 0.0037500000000000003 6.6704936437585212e-06 0.0037600000000000003 7.023604813103202e-06 0.0037700000000000003 -1.0260329628364506e-05 0.0037800000000000004 -2.4981542333000754e-06 0.0037900000000000004 2.73195987750126e-06 0.0038000000000000004 -1.864067163775402e-06 0.0038100000000000005 4.7529908093884595e-06 0.0038200000000000005 8.3958371356850759e-06 0.0038300000000000005 1.5277797370385939e-07 0.0038400000000000005 6.8074487902870209e-06 0.0038500000000000001 -9.0917375239500334e-06 0.0038600000000000001 -6.1012844409226415e-06 0.0038700000000000002 5.079822444916148e-06 0.0038800000000000002 6.1639527978642654e-06 0.0038900000000000002 4.7675971562442296e-07 0.0039000000000000003 4.3519101906463062e-06 0.0039100000000000003 -6.1258389362400158e-06 0.0039200000000000007 -7.9282265437560265e-07 0.0039300000000000003 3.8931894262534126e-06 0.0039399999999999999 7.405995386613677e-06 0.0039500000000000004 -5.0473407816048692e-06 0.00396 5.5096292529336467e-06 0.0039700000000000004 1.7724190600539381e-06 0.00398 -3.090405339998203e-06 0.0039900000000000005 2.302821110216178e-06 0.0040000000000000001 5.5220698937561319e-07 0.0040100000000000005 -7.5089949514822476e-06 0.0040200000000000001 -6.5117525444559857e-06 0.0040300000000000006 4.2290302342003782e-06 0.0040400000000000002 2.4011875874087764e-06 0.0040500000000000006 4.4765980891200066e-07 0.0040600000000000002 -1.5750859900007371e-06 0.0040700000000000007 4.2273350864827899e-06 0.0040800000000000003 1.5756914032747919e-07 0.0040900000000000008 8.8694174843804394e-06 0.0041000000000000003 6.2398576535337339e-06 0.0041099999999999999 -8.4303614178995879e-06 0.0041200000000000004 1.063863493536137e-06 0.00413 1.0574514709874657e-06 0.0041400000000000005 -2.3177899681262728e-06 0.00415 -1.722532982778051e-06 0.0041600000000000005 2.402811593302803e-06 0.0041700000000000001 -9.0303896557087477e-07 0.0041800000000000006 2.0028570922946761e-07 0.0041900000000000001 4.0549587083249361e-06 0.0042000000000000006 -1.4284227000828956e-06 0.0042100000000000002 1.5532645223101687e-06 0.0042200000000000007 -5.2398739509349458e-06 0.0042300000000000003 1.2696029512820837e-06 0.0042400000000000007 4.064439021818601e-06 0.0042500000000000003 1.2235993644175932e-06 0.0042600000000000008 -7.9438857726835928e-06 0.0042700000000000004 -8.0192828471184882e-07 0.00428 3.8912163984864549e-06 0.0042900000000000004 -9.2578837444089867e-06 0.0043 -4.7988314598604394e-06 0.0043100000000000005 -1.0784659441577788e-06 0.0043200000000000001 -8.724319415079514e-07 0.0043300000000000005 5.8286780615841399e-06 0.0043400000000000001 -1.5412819497512321e-06 0.0043500000000000006 7.4976812421507976e-07 0.0043600000000000002 -7.1655919649092023e-06 0.0043700000000000006 -4.7919025544934166e-06 0.0043800000000000002 7.707189440210012e-06 0.0043900000000000007 -9.9738546815949328e-06 0.0044000000000000003 -9.4506435354178613e-07 0.0044100000000000007 -7.3092719348284216e-06 0.0044200000000000003 -7.532598781199274e-06 0.0044300000000000008 7.1467236392938302e-06 0.0044400000000000004 3.1739210350472415e-06 0.00445 1.7566542415370887e-06 0.0044600000000000004 -7.5527101169390525e-07 0.00447 -1.598885205641208e-06 0.0044800000000000005 2.2612149019778307e-06 0.0044900000000000001 -3.5093920849077081e-07 0.0045000000000000005 2.6280911268005792e-06 0.0045100000000000001 -8.2831132337848684e-08 0.0045200000000000006 -6.2866088463041418e-06 0.0045300000000000002 3.202071759456845e-07 0.0045400000000000006 -3.5744753757242611e-07 0.0045500000000000002 1.6356336874692871e-06 0.0045600000000000007 -6.2472381463246829e-07 0.0045700000000000003 5.1239783846622224e-07 0.0045800000000000007 -5.6147020543425688e-06 0.0045900000000000003 6.3002111121127264e-06 0.0046000000000000008 -1.9790249604781513e-06 0.0046100000000000004 -2.1888244372235989e-08 0.00462 7.4437810547808256e-07 0.0046300000000000004 3.0922593083273962e-06 0.00464 6.5907326030541365e-06 0.0046500000000000005 -2.2749316921534995e-06 0.0046600000000000001 4.2190724123253389e-06 0.0046700000000000005 -4.9233503444929245e-06 0.0046800000000000001 -2.1271703328328537e-06 0.0046900000000000006 3.6961155660218446e-06 0.0047000000000000002 2.2902541602996549e-06 0.0047100000000000006 1.0081028526820475e-05 0.0047200000000000002 5.7838610079115111e-06 0.0047300000000000007 -4.905950867280134e-06 0.0047400000000000003 3.6679401801778902e-06 0.0047500000000000007 4.4303095835360434e-06 0.0047600000000000003 5.3883882327134832e-07 0.0047700000000000008 4.6490902995167127e-06 0.0047800000000000004 -4.0697901352325189e-06 0.00479 -1.0339776160985079e-06 0.0048000000000000004 7.0633890462442744e-06 0.00481 2.5869159988694784e-06 0.0048200000000000005 2.4855159284775164e-06 0.0048300000000000001 -1.2524257134269225e-06 0.0048400000000000006 7.5211831661099536e-06 0.0048500000000000001 2.8383945327407526e-06 0.0048600000000000006 1.6411380215368933e-06 0.0048700000000000002 6.2592208990668426e-06 0.0048800000000000007 -5.2056483073385732e-06 0.0048900000000000002 2.1771677341688587e-06 0.0049000000000000007 2.4464294136763353e-06 0.0049100000000000003 -4.3970458600774666e-06 0.0049200000000000008 -7.1708763008354441e-06 0.0049300000000000004 -1.2667196592034964e-06 0.0049400000000000008 4.9245604342030157e-06 0.0049500000000000004 4.0419443760079649e-06 0.00496 -2.589963794948097e-06 0.0049700000000000005 -6.7424156247162703e-07 0.0049800000000000001 -1.8505605270741899e-06 0.0049900000000000005 -3.7415019183002165e-06 0.0050000000000000001 2.288201431798842e-06 0.0050100000000000006 8.1506377660623699e-06 0.0050200000000000002 -1.0533752874996592e-06 0.0050300000000000006 -3.2930021000170273e-07 0.0050400000000000002 -7.080551819230461e-06 0.0050500000000000007 8.1054227859941188e-06 0.0050600000000000003 -2.3940591600713648e-06 0.0050700000000000007 1.0808790417686087e-06 0.0050800000000000003 6.2941469270616205e-07 0.0050900000000000008 -1.9909755951720837e-07 0.0051000000000000004 3.672744269474612e-06 0.0051100000000000008 -4.0269793158451248e-06 0.0051200000000000004 -1.232218781947424e-07 0.00513 6.9817942138078364e-06 0.0051400000000000005 -6.8336138188222192e-06 0.0051500000000000001 1.1761933268720915e-05 0.0051600000000000005 -3.0792495144156149e-06 0.0051700000000000001 4.4676587157260494e-06 0.0051800000000000006 -1.4080819110555902e-06 0.0051900000000000002 -3.6929301823353665e-07 0.0052000000000000006 1.6612931166605058e-06 0.0052100000000000002 -6.1202546022192307e-06 0.0052200000000000007 -4.5005741925014792e-06 0.0052300000000000003 2.4010168707632639e-06 0.0052400000000000007 -7.3080210567360974e-06 0.0052500000000000003 -4.1894167998696493e-06 0.0052600000000000008 -1.4118438499446966e-06 0.0052700000000000004 5.5866029235623254e-06 0.0052800000000000008 -5.1105379691789539e-06 0.0052900000000000004 2.2096648797393115e-06 0.0053 -2.0169986748827493e-06 0.0053100000000000005 -1.0688073277062147e-07 0.0053200000000000001 9.5043811039734888e-06 0.0053300000000000005 -1.5492378285104169e-05 0.0053400000000000001 -1.1733084760915637e-05 0.0053500000000000006 -4.4520365042533986e-06 0.0053600000000000002 -1.7919052591632862e-06 0.0053700000000000006 3.9479427358665728e-06 0.0053800000000000002 1.3369703211652727e-07 0.0053900000000000007 3.9174844259326298e-06 0.0054000000000000003 9.8546765883910125e-07 0.0054100000000000007 3.8936546634738862e-06 0.0054200000000000003 8.3933228810118602e-06 0.0054300000000000008 2.5275431806785249e-06 0.0054400000000000004 -9.9616120462296454e-07 0.0054500000000000009 3.0452998111605459e-06 0.0054600000000000004 9.1681268320817271e-06 0.00547 1.9575769270785741e-06 0.0054800000000000005 -1.0444639026600663e-05 0.0054900000000000001 4.4071409606229962e-06 0.0055000000000000005 -9.087014661124846e-07 0.0055100000000000001 -3.277182054082662e-07 0.0055200000000000006 1.2960290956960407e-05 0.0055300000000000002 1.1836259048994114e-05 0.0055400000000000007 6.9455660646299551e-06 0.0055500000000000002 -1.8348293750999627e-06 0.0055600000000000007 8.0625261145110082e-06 0.0055700000000000003 5.0835901659107041e-06 0.0055800000000000008 4.4891336380220239e-06 0.0055900000000000004 -3.0222121941770812e-06 0.0056000000000000008 4.8537767916948967e-06 0.0056100000000000004 9.1251757462135855e-06 0.0056200000000000009 -6.3603279811297439e-07 0.0056300000000000005 -2.5653213471689376e-06 0.00564 5.4590088174608247e-06 0.0056500000000000005 3.6170478275823165e-07 0.0056600000000000001 5.0556186205834081e-06 0.0056700000000000006 3.1423506072431093e-06 0.0056800000000000002 1.2760216823331745e-06 0.0056900000000000006 -2.6966827747128112e-06 0.0057000000000000002 -6.2246446854570377e-07 0.0057100000000000007 1.5919417919669588e-07 0.0057200000000000003 1.302888955188008e-07 0.0057300000000000007 -3.3949455470260607e-06 0.0057400000000000003 -2.4081661276510949e-06 0.0057500000000000008 5.9519828677874583e-06 0.0057600000000000004 1.196085724444208e-06 0.0057700000000000008 -6.7725183868956649e-06 0.0057800000000000004 -2.5623304314740411e-06 0.0057900000000000009 2.2699800020393679e-06 0.0058000000000000005 -3.3803791656613658e-06 0.0058100000000000001 -3.7049361712211428e-06 0.0058200000000000005 -2.7613381069230805e-06 0.0058300000000000001 -2.4064505691099486e-06 0.0058400000000000006 2.6545170772562691e-06 0.0058500000000000002 2.2666470438404126e-06 0.0058600000000000006 7.1467528102897385e-07 0.0058700000000000002 6.1033370670569058e-06 0.0058800000000000007 -5.9487293232477869e-06 0.0058900000000000003 6.5983174274619478e-06 0.0059000000000000007 -8.1321554275763788e-06 0.0059100000000000003 1.3106086214565908e-06 0.0059200000000000008 5.9441954166847119e-06 0.0059300000000000004 1.20132597995704e-05 0.0059400000000000008 -3.6032330883726117e-07 0.0059500000000000004 -1.0504685742579665e-05 0.0059600000000000009 -9.9177832954062169e-06 0.0059700000000000005 -9.0487697587344287e-06 0.0059800000000000001 2.9358129415796595e-06 0.0059900000000000005 4.8270419019571802e-06 0.0060000000000000001 3.4733180807744822e-06 0.0060100000000000006 3.8592203110182264e-06 0.0060200000000000002 5.6045376941307963e-06 0.0060300000000000006 -3.2784707595536893e-06 0.0060400000000000002 6.2555062008695591e-06 0.0060500000000000007 -8.698632836135129e-06 0.0060600000000000003 5.2728331912781626e-06 0.0060700000000000007 7.7186112987829636e-06 0.0060800000000000003 2.7767834358419139e-06 0.0060900000000000008 -3.2372737575461583e-06 0.0061000000000000004 2.3135448788009293e-06 0.0061100000000000008 7.6163487189235176e-06 0.0061200000000000004 1.6289689446095567e-06 0.0061300000000000009 9.2193018702650326e-06 0.0061400000000000005 5.1505865604139228e-06 0.0061500000000000001 -8.9600298921740875e-06 0.0061600000000000005 -5.4402197485156314e-06 0.0061700000000000001 -2.3522056378172171e-06 0.0061800000000000006 -1.6480427561109817e-06 0.0061900000000000002 -9.8170167384052783e-07 0.0062000000000000006 5.0780443977393314e-06 0.0062100000000000002 -7.9434848119596262e-07 0.0062200000000000007 6.4529700193246411e-06 0.0062300000000000003 -3.9928089538238224e-06 0.0062400000000000008 -1.6203370129811682e-06 0.0062500000000000003 4.6076781596287526e-06 0.0062600000000000008 -3.0896295579012164e-06 0.0062700000000000004 -4.5169448774883619e-06 0.0062800000000000009 -3.1913552314693917e-06 0.0062900000000000005 -5.962802050042258e-06 0.0063000000000000009 7.2700521606212362e-06 0.0063100000000000005 4.7830538662455698e-07 0.0063200000000000001 -7.0837856571941762e-06 0.0063300000000000006 -6.9386408681192906e-06 0.0063400000000000001 4.1392989643584181e-06 0.0063500000000000006 4.6594209803436348e-07 0.0063600000000000002 1.8462665359795939e-06 0.0063700000000000007 4.3467969575511935e-06 0.0063800000000000003 -6.1628127123310087e-06 0.0063900000000000007 4.1719562611733543e-06 0.0064000000000000003 4.340978979194276e-06 0.0064100000000000008 3.6300135399476749e-06 0.0064200000000000004 -2.749046581317895e-06 0.0064300000000000008 -3.9194317571918445e-06 0.0064400000000000004 3.3547796485979268e-06 0.0064500000000000009 7.4834969419844592e-06 0.0064600000000000005 -1.921960459494202e-06 0.0064700000000000009 -6.5335264070377768e-06 0.0064800000000000005 -7.4589858234634769e-06 0.0064900000000000001 -2.5989772001175194e-06 0.0065000000000000006 4.5006663186083441e-07 0.0065100000000000002 4.0927249870602485e-06 0.0065200000000000006 2.6914945515621917e-06 0.0065300000000000002 1.4465040336002092e-06 0.0065400000000000007 1.2951165886542122e-06 0.0065500000000000003 1.2831749233307682e-05 0.0065600000000000007 -9.7352331950488838e-06 0.0065700000000000003 -5.2627764486004159e-06 0.0065800000000000008 -4.4389547249087696e-06 0.0065900000000000004 2.0785756309434018e-06 0.0066000000000000008 1.9292469821911131e-06 0.0066100000000000004 -4.6605798079362518e-06 0.0066200000000000009 4.2636914698255579e-06 0.0066300000000000005 -1.6056511970707917e-07 0.0066400000000000009 4.0425777016620169e-07 0.0066500000000000005 1.8792887395925576e-07 0.0066600000000000001 1.5876728825465939e-06 0.0066700000000000006 -3.5508516334897874e-06 0.0066800000000000002 7.4489508548819487e-07 0.0066900000000000006 -4.7056016064343106e-06 0.0067000000000000002 2.101199474607915e-06 0.0067100000000000007 1.5489749802567583e-06 0.0067200000000000003 1.4205163106326492e-06 0.0067300000000000007 1.2605689017179948e-05 0.0067400000000000003 -2.8470024541486365e-07 0.0067500000000000008 -2.6562129815924687e-06 0.0067600000000000004 2.8294616883214902e-06 0.0067700000000000008 7.7423731687301067e-06 0.0067800000000000004 -9.8468152896695636e-06 0.0067900000000000009 -2.0155129878266142e-06 0.0068000000000000005 5.4712935469177396e-06 0.0068100000000000009 2.7140079028778284e-06 0.0068200000000000005 2.9349389697643332e-06 0.0068300000000000001 4.8238065555219693e-06 0.0068400000000000006 3.3359243241990975e-06 0.0068500000000000002 -2.5444654957141481e-06 0.0068600000000000006 4.0157717964145001e-06 0.0068700000000000002 7.3172655190138966e-06 0.0068800000000000007 1.3532733540445204e-06 0.0068900000000000003 -1.2697160882988952e-05 0.0069000000000000008 2.9216869318165716e-06 0.0069100000000000003 -2.8813052680315332e-06 0.0069200000000000008 -6.8344517740673113e-06 0.0069300000000000004 -1.0552229731206138e-05 0.0069400000000000009 -2.8806084488953658e-07 0.0069500000000000004 -1.0483076251443679e-06 0.0069600000000000009 7.5827048037936758e-06 0.0069700000000000005 -1.9714656115233067e-06 0.006980000000000001 -7.6285092599380336e-06 0.0069900000000000006 -4.7789950864540754e-06 0.0070000000000000001 -6.3901114058140425e-06 0.0070100000000000006 -6.7606149477427568e-08 0.0070200000000000002 3.1680786711451667e-06 0.0070300000000000007 -2.8707223513054233e-06 0.0070400000000000003 5.4474473468451603e-07 0.0070500000000000007 5.0920276387561711e-06 0.0070600000000000003 -6.9319012734541388e-06 0.0070700000000000008 -6.5462581833919814e-06 0.0070800000000000004 7.468353371511848e-08 0.0070900000000000008 2.721041992595524e-06 0.0071000000000000004 -5.7980234527398801e-06 0.0071100000000000009 -3.1884048631988539e-06 0.0071200000000000005 9.3684258652491802e-06 0.0071300000000000009 -4.3734568485861653e-06 0.0071400000000000005 5.3155542196298059e-06 0.007150000000000001 -1.6238004851158499e-07 0.0071600000000000006 -5.2967552391783849e-06 0.0071700000000000002 1.0028742760408137e-06 0.0071800000000000006 -5.1570811639951558e-07 0.0071900000000000002 1.1502223220169746e-05 0.0072000000000000007 -1.8308409612803086e-06 0.0072100000000000003 5.4186969769402239e-06 0.0072200000000000007 6.0108545944403086e-06 0.0072300000000000003 1.0076505702229145e-06 0.0072400000000000008 1.4179152324578538e-05 0.0072500000000000004 -5.9930284948651962e-06 0.0072600000000000008 4.5434649204009734e-07 0.0072700000000000004 -7.0820672633761257e-06 0.0072800000000000009 -3.725403087686606e-06 0.0072900000000000005 1.9662177888778176e-06 0.0073000000000000009 3.6607691935490795e-06 0.0073100000000000005 5.605864373270684e-06 0.007320000000000001 -5.9883145730341559e-06 0.0073300000000000006 1.9295584524753483e-06 0.0073400000000000002 8.0005658004559508e-06 0.0073500000000000006 -1.2201418099587624e-06 0.0073600000000000002 9.081229083130915e-06 0.0073700000000000007 -8.2353115628036479e-06 0.0073800000000000003 6.4866946137562936e-06 0.0073900000000000007 -3.9466749775550768e-06 0.0074000000000000003 -1.4750279282217106e-06 0.0074100000000000008 2.0804986067246897e-06 0.0074200000000000004 -3.9594323819820875e-06 0.0074300000000000008 1.4249468470552634e-05 0.0074400000000000004 1.031546254852539e-05 0.0074500000000000009 4.7604294141729078e-06 0.0074600000000000005 4.2068443613004218e-06 0.0074700000000000009 1.2419280093361329e-06 0.0074800000000000005 7.3857648712006345e-08 0.007490000000000001 -5.9413267216577618e-06 0.0075000000000000006 2.4759353031787749e-06 0.0075100000000000002 -3.0734002088254577e-06 0.0075200000000000006 -9.9648540988595134e-06 0.0075300000000000002 -1.1662963641607822e-06 0.0075400000000000007 -1.9345202642391383e-06 0.0075500000000000003 1.0806934480820563e-05 0.0075600000000000007 -8.969682520459441e-07 0.0075700000000000003 -6.8116156036964619e-06 0.0075800000000000008 9.3650260128508912e-06 0.0075900000000000004 3.2787060027226246e-06 0.0076000000000000009 -7.7471376321739738e-06 0.0076100000000000004 -4.0797752841737777e-07 0.0076200000000000009 5.9902202137027447e-07 0.0076300000000000005 3.8407318434001196e-06 0.007640000000000001 -2.7944704640068009e-06 0.0076500000000000005 2.9538741884938255e-06 0.007660000000000001 -1.5082381653414935e-06 0.0076700000000000006 1.4221849089865988e-07 0.0076800000000000011 2.2486935808701203e-06 0.0076900000000000007 -7.399965692852387e-06 0.0077000000000000002 -5.5096294139378936e-07 0.0077100000000000007 -2.5005609766735349e-06 0.0077200000000000003 5.8414119038369356e-06 0.0077300000000000008 1.8444361833964916e-06 0.0077400000000000004 1.4804959456163597e-06 0.0077500000000000008 -1.0095714327092405e-05 0.0077600000000000004 2.998727640558426e-06 0.0077700000000000009 -7.682398727734561e-06 0.0077800000000000005 2.9220355093381403e-06 0.0077900000000000009 5.622856754358281e-06 0.0078000000000000005 6.8828115593768997e-06 0.007810000000000001 7.8493728869049728e-07 0.0078200000000000006 2.3320648150255872e-06 0.0078300000000000002 2.8367752712038684e-06 0.0078400000000000015 -8.913740680840826e-06 0.0078500000000000011 1.6027321560473852e-06 0.0078600000000000007 1.9808351273907083e-08 0.0078700000000000003 -3.7113055685906041e-07 0.0078799999999999999 2.1678268150290937e-06 0.0078900000000000012 -2.74007016863466e-07 0.0079000000000000008 2.5734396114338456e-06 0.0079100000000000004 -1.2419626991170015e-06 0.00792 -4.6048052434538946e-08 0.0079300000000000013 -4.3766738115209303e-06 0.0079400000000000009 6.2312235508288355e-07 0.0079500000000000005 -6.5220391895647695e-06 0.0079600000000000001 -2.0373069817072435e-06 0.0079700000000000014 -5.0237784939788083e-06 0.007980000000000001 -5.7257592407678919e-06 0.0079900000000000006 2.4924950004215077e-06 0.0080000000000000002 -5.1893980382903406e-06 0.0080100000000000015 1.9890094119334742e-06 0.0080200000000000011 1.9271656113198683e-06 0.0080300000000000007 -3.957674066344451e-06 0.0080400000000000003 -3.7608337429316704e-06 0.0080499999999999999 2.8357047378792498e-06 0.0080600000000000012 -1.1821796357702024e-06 0.0080700000000000008 1.0844945709910537e-06 0.0080800000000000004 1.5013173735967143e-06 0.00809 1.120290441679197e-06 0.0081000000000000013 -4.003528622257718e-06 0.0081100000000000009 -6.4044389349786932e-06 0.0081200000000000005 -9.2373290345821189e-06 0.0081300000000000001 -1.3211267403758198e-05 0.0081400000000000014 -5.1894099530392725e-06 0.008150000000000001 -4.2715369530881391e-06 0.0081600000000000006 -5.1971048356627707e-06 0.0081700000000000002 2.8361321843488727e-06 0.0081800000000000015 -7.0144641125414681e-06 0.0081900000000000011 3.5684286941738507e-06 0.0082000000000000007 -2.034822454314837e-06 0.0082100000000000003 2.7361699971665496e-06 0.0082199999999999999 -7.276723659721305e-06 0.0082300000000000012 1.627791638268364e-06 0.0082400000000000008 -3.6790551865555896e-06 0.0082500000000000004 -7.3729437503511678e-06 0.00826 9.9242620566949088e-06 0.0082700000000000013 -1.4828179819177919e-06 0.0082800000000000009 5.9137051213892735e-06 0.0082900000000000005 3.7591467310469899e-06 0.0083000000000000001 -1.0029888795722596e-05 0.0083100000000000014 -3.2749676538658818e-06 0.008320000000000001 -4.1085089167254052e-06 0.0083300000000000006 -2.8921489707715473e-06 0.0083400000000000002 -4.8393609465421199e-06 0.0083500000000000015 -7.565210790081335e-06 0.0083600000000000011 -4.4123546337051384e-06 0.0083700000000000007 6.7453933563670311e-06 0.0083800000000000003 2.7458501538433542e-07 0.0083899999999999999 -7.6792334384340922e-06 0.0084000000000000012 -7.1989857108622296e-06 0.0084100000000000008 -1.4425287776095686e-06 0.0084200000000000004 4.8345799492847643e-06 0.00843 -1.3845700703702266e-06 0.0084400000000000013 3.6395436465456173e-06 0.0084500000000000009 2.1774274700638968e-06 0.0084600000000000005 3.5892582164802318e-06 0.0084700000000000001 1.2056206518836191e-06 0.0084800000000000014 3.5098553735362471e-06 0.008490000000000001 2.5999310976999731e-06 0.0085000000000000006 4.5475322151530315e-06 0.0085100000000000002 -2.700190535345692e-06 0.0085200000000000015 5.1700230145718314e-06 0.0085300000000000011 -3.999062376628262e-07 0.0085400000000000007 2.1574501660857941e-09 0.0085500000000000003 3.9109105162797374e-06 0.0085599999999999999 -2.5246557909175989e-06 0.0085700000000000012 2.6738782730355616e-06 0.0085800000000000008 2.5726717446976247e-08 0.0085900000000000004 2.6808073777477279e-06 0.0086 -8.3768731310696331e-06 0.0086100000000000013 -7.6871009177377906e-06 0.0086200000000000009 -3.1692156959077732e-06 0.0086300000000000005 -7.4469950043312052e-06 0.0086400000000000001 9.8046234256134601e-06 0.0086500000000000014 -2.9000842969691495e-06 0.008660000000000001 9.8024646151233511e-07 0.0086700000000000006 5.7993596908764945e-06 0.0086800000000000002 3.2576806655518202e-06 0.0086900000000000015 -9.8223171297642301e-06 0.0087000000000000011 1.0090001643532598e-05 0.0087100000000000007 1.010539343182468e-05 0.0087200000000000003 5.36021837344329e-06 0.0087299999999999999 -8.271277381977459e-07 0.0087400000000000012 6.691115070513047e-06 0.0087500000000000008 1.5026436416449716e-06 0.0087600000000000004 -4.5935830531801112e-06 0.00877 3.4101195642750929e-08 0.0087800000000000013 1.9730536261512033e-06 0.0087900000000000009 1.6476262434746681e-06 0.0088000000000000005 1.6140214435092405e-06 0.0088100000000000001 8.0426531802702188e-07 0.0088200000000000014 -1.1099182343892427e-05 0.008830000000000001 -5.0230527130648956e-06 0.0088400000000000006 6.032878909607215e-06 0.0088500000000000002 -7.1127264149444256e-06 0.0088600000000000016 -4.8573858853049452e-06 0.0088700000000000011 -8.1477911155862605e-06 0.0088800000000000007 6.3540668217077584e-06 0.0088900000000000003 -4.7759173399736006e-06 0.0088999999999999999 -9.7282507399314836e-06 0.0089100000000000013 -1.2411194354326011e-06 0.0089200000000000008 -2.3773537617604854e-06 0.0089300000000000004 -5.0411619927786379e-06 0.00894 -6.2588137273599412e-06 0.0089500000000000014 -1.8070718513269425e-06 0.0089600000000000009 -7.1845809876498508e-06 0.0089700000000000005 6.8358180191585011e-06 0.0089800000000000001 -6.0054655540873229e-06 0.0089900000000000015 -4.8132144056874811e-06 0.0090000000000000011 -7.0687241381783274e-06 0.0090100000000000006 1.1066963276100747e-06 0.0090200000000000002 -4.9866136647886311e-06 0.0090300000000000016 -2.507331830551555e-06 0.0090400000000000012 2.8442673802123777e-06 0.0090500000000000008 3.9241935860924755e-06 0.0090600000000000003 -3.1781324676725919e-06 0.0090699999999999999 -1.3707962745717425e-05 0.0090800000000000013 7.6710705013775486e-07 0.0090900000000000009 3.5707297546486745e-06 0.0091000000000000004 -9.1509629506233762e-06 0.00911 -6.6452417544741157e-07 0.0091200000000000014 -1.6708217761176393e-06 0.009130000000000001 3.1059450546375053e-06 0.0091400000000000006 -2.5662184710779117e-06 0.0091500000000000001 1.4548667218558566e-06 0.0091600000000000015 6.5252036600819165e-06 0.0091700000000000011 -6.3001501201982643e-07 0.0091800000000000007 -6.1320651030255807e-06 0.0091900000000000003 1.762268594636295e-06 0.0092000000000000016 2.0451407059207539e-06 0.0092100000000000012 -1.2670020039090269e-06 0.0092200000000000008 -4.5150402444852057e-06 0.0092300000000000004 4.1466399445878429e-06 0.0092399999999999999 4.5942018812736973e-07 0.0092500000000000013 8.6038421422756108e-07 0.0092600000000000009 -8.0542932705644946e-06 0.0092700000000000005 2.4498473355326348e-06 0.0092800000000000001 1.3606769638911375e-06 0.0092900000000000014 -2.7609283468496929e-06 0.009300000000000001 -5.4235090878562261e-06 0.0093100000000000006 4.6591836314259574e-06 0.0093200000000000002 -4.5505840994619998e-06 0.0093300000000000015 -1.7153266134660953e-05 0.0093400000000000011 6.3554942486856976e-06 0.0093500000000000007 -4.6227177304693684e-06 0.0093600000000000003 -2.2678198076952549e-06 0.0093700000000000016 -6.2426695910883242e-06 0.0093800000000000012 -5.4200166962458871e-06 0.0093900000000000008 -2.353972807934808e-06 0.0094000000000000004 -2.5353919905871817e-06 0.00941 -3.5983124135563579e-06 0.0094200000000000013 1.9379962866734981e-06 0.0094300000000000009 -1.175131435708716e-05 0.0094400000000000005 1.2278949182352994e-05 0.0094500000000000001 6.9568461271615158e-06 0.0094600000000000014 1.0861732144253803e-06 0.009470000000000001 1.0092986883318016e-07 0.0094800000000000006 2.101193878639406e-06 0.0094900000000000002 -4.752078902250641e-06 0.0095000000000000015 9.6415606520395998e-06 0.0095100000000000011 3.6309342689067408e-06 0.0095200000000000007 3.848025098933485e-06 0.0095300000000000003 -8.1741244520443968e-06 0.0095400000000000016 -4.4754354255879709e-06 0.0095500000000000012 -2.5457480921196807e-06 0.0095600000000000008 1.2836709646395749e-06 0.0095700000000000004 -3.1341008285658187e-06 0.00958 3.4824278843487207e-06 0.0095900000000000013 6.3616026843716541e-09 0.0096000000000000009 1.6845168928028466e-06 0.0096100000000000005 -5.5770798702710645e-06 0.0096200000000000001 -9.1988196844388873e-06 0.0096300000000000014 -6.6607141781347392e-06 0.009640000000000001 8.8779407249747101e-07 0.0096500000000000006 -8.8159532788015114e-07 0.0096600000000000002 4.6015479662446922e-06 0.0096700000000000015 -6.7220080992246984e-06 0.0096800000000000011 2.9282006815207851e-06 0.0096900000000000007 1.7916370692791311e-06 0.0097000000000000003 -4.9905227694256813e-06 0.0097100000000000016 -3.6008406882568247e-06 0.0097200000000000012 5.030842256843822e-06 0.0097300000000000008 -2.714302060274576e-08 0.0097400000000000004 4.1410083950857103e-06 0.00975 1.7868192577337896e-06 0.0097600000000000013 3.6927140269349737e-06 0.0097700000000000009 -3.1989519266118395e-06 0.0097800000000000005 -2.4453090557045089e-07 0.0097900000000000001 1.2905962328917132e-06 0.0098000000000000014 -5.3191092452476182e-06 0.009810000000000001 -9.5775671235030815e-06 0.0098200000000000006 6.8454446053191371e-06 0.0098300000000000002 -5.218102191437969e-07 0.0098400000000000015 -2.3564694612713769e-06 0.0098500000000000011 6.7084731458477704e-06 0.0098600000000000007 1.4803929354498788e-06 0.0098700000000000003 8.4626468354288338e-07 0.0098800000000000016 -1.1113914634468907e-06 0.0098900000000000012 -1.9977820004479158e-06 0.0099000000000000008 -1.1590426368905991e-06 0.0099100000000000004 5.902063809463843e-06 0.00992 -5.6598462009487401e-07 0.0099300000000000013 4.4991926936726209e-06 0.0099400000000000009 3.3213553051389846e-06 0.0099500000000000005 -1.2150463108314171e-06 0.0099600000000000001 8.2946320439479396e-06 0.0099700000000000014 4.4614844333535333e-08 0.009980000000000001 5.8929947522700559e-06 0.0099900000000000006 2.6776244441307837e-06 0.01 -5.8686457632308166e-06 0.010010000000000002 8.7948395467708848e-06 0.010020000000000001 3.2344397302745219e-06 0.010030000000000001 -6.8908976667339599e-07 0.01004 -1.8543687922124338e-06 0.010050000000000002 -2.1583534963601942e-06 0.010060000000000001 -2.1629235063233405e-08 0.010070000000000001 1.852388567144976e-06 0.01008 6.3196967183022374e-06 0.01009 1.0325879149455408e-06 0.010100000000000001 3.3101958502298514e-06 0.010110000000000001 4.7911168363819452e-06 0.010120000000000001 1.0170256245814802e-05 0.01013 5.1986868206427099e-06 0.010140000000000001 6.2200028286666126e-06 0.010150000000000001 4.8036382198563095e-06 0.010160000000000001 5.5106380272819563e-06 0.01017 2.5563230679896207e-06 0.010180000000000002 1.2714153257517221e-06 0.010190000000000001 4.8701883347551305e-06 0.010200000000000001 1.7551803107139597e-06 0.01021 1.0804752553745279e-05 0.010220000000000002 -1.5186635765625912e-06 0.010230000000000001 1.6429527692381635e-07 0.010240000000000001 -2.3842391922777555e-06 0.01025 -7.8935163079852231e-07 0.01026 -2.7926450231372474e-06 0.010270000000000001 -8.0845343503666862e-07 0.010280000000000001 8.4379724040144853e-07 0.010290000000000001 -3.6103126846701016e-06 0.0103 1.8992169175886881e-06 0.010310000000000001 -1.5958552467503724e-06 0.010320000000000001 1.5378068752736395e-06 0.010330000000000001 4.4333129453470026e-07 0.01034 7.1983143285011367e-07 0.010350000000000002 -1.1488560268652249e-07 0.010360000000000001 -3.6680741475901787e-06 0.010370000000000001 9.7101243142449754e-07 0.01038 -3.0177521434339052e-06 0.010390000000000002 -2.0793515986950447e-06 0.010400000000000001 1.5170822958661364e-06 0.010410000000000001 4.9887974994958513e-06 0.01042 -2.0403080965292833e-06 0.01043 2.1995218247787916e-06 0.010440000000000001 -1.1515884808704351e-05 0.010450000000000001 4.8189620294969934e-06 0.010460000000000001 1.8450807425742493e-06 0.01047 7.4765031905042974e-06 0.010480000000000001 -4.5229623157464744e-06 0.010490000000000001 -3.2342799315258387e-06 0.010500000000000001 4.6894736287139744e-06 0.01051 4.0089514090759728e-07 0.010520000000000002 -1.3659097585671813e-06 0.010530000000000001 5.0072358485584841e-06 0.010540000000000001 8.4569273226882576e-06 0.01055 6.5845006635895457e-06 0.010560000000000002 1.0757796686651807e-05 0.010570000000000001 -5.0555292969163428e-06 0.010580000000000001 -4.1895301218458613e-06 0.01059 4.3464063441667399e-07 0.0106 -1.7009680795305345e-06 0.010610000000000001 -3.5522300808122283e-06 0.010620000000000001 1.9052088010156352e-07 0.010630000000000001 5.8987469037185215e-06 0.01064 -8.6320289848168771e-07 0.010650000000000001 -4.93870378717605e-06 0.010660000000000001 -1.6869100969499838e-06 0.010670000000000001 9.0816670894940279e-07 0.01068 8.0631399275015565e-08 0.010690000000000002 -1.318276176445679e-06 0.010700000000000001 -3.2681343263297265e-06 0.010710000000000001 -3.5302226321993111e-06 0.01072 1.1675705718218986e-05 0.010730000000000002 1.8175204383111391e-06 0.010740000000000001 -6.446335318268695e-06 0.010750000000000001 -3.1042885275773051e-06 0.01076 6.1130817062770305e-07 0.01077 3.4938847897349255e-06 0.010780000000000001 -4.1778670791145883e-06 0.010790000000000001 3.6302363597757088e-06 0.010800000000000001 -3.1728214556181845e-06 0.01081 1.0183587881561023e-06 0.010820000000000001 -1.8841408003158737e-06 0.010830000000000001 -9.9785225182485563e-07 0.010840000000000001 8.7704360292162438e-07 0.01085 -3.038939997915316e-06 0.010860000000000002 -1.472598910731332e-06 0.010870000000000001 1.0031765862649504e-06 0.010880000000000001 1.1089602585300825e-06 0.01089 -8.3379881009238852e-06 0.010900000000000002 -8.9592222852028008e-06 0.010910000000000001 -2.2782526777706001e-06 0.010920000000000001 1.8831666416828484e-06 0.01093 -1.7381664004272785e-07 0.01094 -4.9748331149513419e-07 0.010950000000000001 4.6544593496941057e-07 0.010960000000000001 -2.0615701571763014e-06 0.010970000000000001 -7.763251419472757e-06 0.01098 -8.6214491393722183e-06 0.010990000000000002 -4.8457351656712122e-06 0.011000000000000001 2.7872727545522244e-06 0.011010000000000001 3.895545279924001e-06 0.01102 2.684343254396183e-06 0.011030000000000002 4.2362241548358017e-06 0.011040000000000001 -3.754890949345832e-06 0.011050000000000001 6.9211445379282678e-07 0.01106 -1.2022333195774083e-06 0.011070000000000002 7.3973334782914877e-06 0.011080000000000001 -2.1853595234354644e-06 0.011090000000000001 6.0494828382245771e-07 0.0111 -4.4893674382129428e-06 0.01111 3.1656302124349236e-06 0.011120000000000001 -2.0201571396760384e-06 0.011130000000000001 -2.4996302871892937e-06 0.011140000000000001 -1.9675082927645788e-06 0.01115 1.5859207726976762e-06 0.011160000000000002 -4.4657559498847884e-06 0.011170000000000001 3.3833658426052906e-07 0.011180000000000001 -3.9987796799222141e-06 0.01119 7.4057962543599963e-06 0.011200000000000002 -1.304013566825152e-06 0.011210000000000001 -6.860286454445948e-06 0.011220000000000001 2.2039893558822374e-07 0.01123 1.0845260119621172e-05 0.011240000000000002 8.5959598353044377e-06 0.011250000000000001 1.2410047842652194e-06 0.011260000000000001 8.85951460437656e-06 0.011270000000000001 7.7076733096751305e-06 0.01128 -8.3693998709953271e-07 0.011290000000000001 -5.3455671715327405e-07 0.011300000000000001 -2.8142382359544791e-06 0.011310000000000001 6.1960432053139887e-06 0.01132 -1.2632775806873937e-06 0.011330000000000002 -5.1247622316822066e-06 0.011340000000000001 3.4769026219083736e-06 0.011350000000000001 3.073138165810199e-06 0.01136 -1.401195344101326e-06 0.011370000000000002 1.0953926596926644e-05 0.011380000000000001 8.3112788571036535e-07 0.011390000000000001 1.129788378569543e-06 0.0114 1.5348164306238495e-06 0.011410000000000002 1.1357654669664899e-07 0.011420000000000001 -4.3041817802930639e-06 0.011430000000000001 -1.2879603005032739e-05 0.011440000000000001 4.09609690487684e-07 0.01145 -4.1199178067487091e-06 0.011460000000000001 3.0183705688756456e-07 0.011470000000000001 -6.5218567773977205e-06 0.011480000000000001 5.748090471973411e-06 0.01149 -3.3359349946222204e-06 0.011500000000000002 -1.5831299789178765e-06 0.011510000000000001 -1.1132326962282047e-07 0.011520000000000001 2.2051550079298962e-07 0.01153 2.6014119264037451e-06 0.011540000000000002 -3.4478944987261785e-06 0.011550000000000001 9.4159920328508336e-06 0.011560000000000001 -5.3791041124618629e-06 0.01157 1.1561107890050211e-06 0.011580000000000002 5.6971089080542971e-06 0.011590000000000001 -1.8408925711072459e-06 0.011600000000000001 -4.7984009002560885e-06 0.011610000000000001 1.4886650978775697e-06 0.01162 -1.4599602608874661e-06 0.011630000000000001 -5.3539871428951919e-06 0.011640000000000001 -5.7999362223775391e-06 0.011650000000000001 9.5534445581299949e-06 0.01166 -3.7384199927595588e-06 0.011670000000000002 -9.1576970242577925e-08 0.011680000000000001 -3.4717242527569201e-06 0.011690000000000001 3.1670037555258572e-06 0.0117 -3.3023854643916131e-06 0.011710000000000002 9.5783657456326991e-06 0.011720000000000001 -1.3308623249039982e-06 0.011730000000000001 6.8216289575976571e-06 0.01174 6.9615269660588747e-06 0.011750000000000002 1.6360247451974599e-06 0.011760000000000001 1.2739354711527868e-06 0.011770000000000001 4.2113424148611671e-06 0.011780000000000001 1.1322247070241592e-06 0.01179 5.0076149248135083e-07 0.011800000000000001 2.7833463476864776e-06 0.011810000000000001 -5.6045793918888609e-07 0.011820000000000001 3.0835380866140986e-06 0.01183 7.0638320826341369e-07 0.011840000000000002 -1.4168847991510439e-06 0.011850000000000001 -2.0944556828948818e-06 0.011860000000000001 -1.3507624798953297e-06 0.01187 1.3653824807419973e-06 0.011880000000000002 -1.3331984919568731e-05 0.011890000000000001 2.753982377717886e-06 0.011900000000000001 1.9100263059135927e-06 0.01191 9.7815444724198613e-06 0.011920000000000002 -6.0894763177158998e-06 0.011930000000000001 4.5940004840104232e-07 0.011940000000000001 3.3195390079726046e-06 0.011950000000000001 6.4617198387688616e-06 0.01196 -4.0769398013184833e-06 0.011970000000000001 5.226486913929874e-07 0.011980000000000001 -1.3153882956975483e-06 0.011990000000000001 -3.9906640719329877e-06 0.012 -1.149487306954783e-06 0.012010000000000002 3.3192387212154654e-06 0.012020000000000001 -3.7267910941765863e-07 0.012030000000000001 -4.459944422302128e-06 0.01204 9.3092690803066243e-07 0.012050000000000002 -4.8873911255733097e-08 0.012060000000000001 2.1633347427078067e-06 0.012070000000000001 2.3931341373832888e-06 0.01208 1.3547269800747906e-06 0.012090000000000002 4.8549926389090289e-06 0.012100000000000001 8.4289902468766678e-06 0.012110000000000001 -1.4779492529909697e-06 0.012120000000000001 1.9877160323196984e-06 0.01213 7.5113666036626032e-06 0.012140000000000001 4.7077691830168845e-06 0.012150000000000001 -2.7642719305898585e-06 0.012160000000000001 1.8483861456636245e-06 0.01217 -2.7236405007550058e-06 0.012180000000000002 3.0472792523495241e-06 0.012190000000000001 -5.6273431946007574e-06 0.012200000000000001 4.3129752826205354e-06 0.01221 6.8088288148367987e-06 0.012220000000000002 -8.0629593307602648e-07 0.012230000000000001 -9.806483067969783e-06 0.012240000000000001 -3.5405913062078213e-06 0.01225 -6.6705084388816057e-06 0.012260000000000002 -2.7457877228821329e-06 0.012270000000000001 -8.9601941137676358e-06 0.012280000000000001 3.3561544742752467e-06 0.012290000000000001 -6.9568636859595051e-06 0.0123 2.2516777570971209e-06 0.012310000000000001 -1.1115917636524953e-06 0.012320000000000001 -2.2035751497822171e-06 0.012330000000000001 3.5890806727631858e-06 0.01234 -2.6562785102208343e-06 0.012350000000000002 6.949989486115707e-06 0.012360000000000001 1.2234278031644065e-06 0.012370000000000001 -3.0087405148302527e-06 0.01238 -3.0528633527328254e-06 0.012390000000000002 -8.7133340227949049e-06 0.012400000000000001 3.8391994515814994e-06 0.012410000000000001 5.164068961640106e-06 0.01242 -1.4386319446343264e-06 0.012430000000000002 -5.3451819662392827e-06 0.012440000000000001 8.1495113679579145e-06 0.012450000000000001 -1.0782971659473724e-06 0.012460000000000001 -3.2569203684780458e-06 0.01247 6.0513336902175477e-06 0.012480000000000002 3.1871966019732214e-06 0.012490000000000001 2.396520371154543e-06 0.012500000000000001 1.0358746433030029e-06 0.01251 -4.6989492636295686e-07 0.012520000000000002 6.2984364672533822e-06 0.012530000000000001 8.9178533515006444e-06 0.012540000000000001 1.1619551646456833e-06 0.01255 -9.3935293678960027e-06 0.012560000000000002 -1.3186777938652209e-07 0.012570000000000001 -7.3650639915273461e-06 0.012580000000000001 9.0822954751520789e-06 0.01259 -2.5854032211796726e-06 0.012600000000000002 2.002059929266197e-07 0.012610000000000001 4.0279440558816015e-06 0.012620000000000001 6.9947706433898078e-06 0.012630000000000001 -2.5618855457596687e-06 0.01264 5.9734573989674712e-06 0.012650000000000002 -2.9194269510561751e-08 0.012660000000000001 9.7572476033132145e-07 0.012670000000000001 7.9770086078658545e-06 0.01268 -1.1998989746046996e-05 0.012690000000000002 5.6689658724468041e-06 0.012700000000000001 -1.1584799312580723e-05 0.012710000000000001 8.5905075432550409e-06 0.01272 1.9095703344125356e-06 0.012730000000000002 7.364172190742974e-06 0.012740000000000001 -1.7718473075079361e-06 0.012750000000000001 -1.9350382545489683e-07 0.012760000000000001 5.7087565752358432e-07 0.012770000000000002 1.8269581409101928e-06 0.012780000000000001 -4.9901177542246879e-06 0.012790000000000001 1.1962631030615028e-06 0.012800000000000001 -9.7405538175545148e-07 0.01281 -9.4299900173855601e-06 0.012820000000000002 4.815705681776526e-06 0.012830000000000001 -3.1003009563945863e-06 0.012840000000000001 8.119879410661872e-06 0.01285 -6.5706730885095414e-06 0.012860000000000002 -2.3878725165469862e-06 0.012870000000000001 -6.5172611541640539e-06 0.012880000000000001 -4.0694877916488247e-06 0.01289 6.059283975014157e-06 0.012900000000000002 -2.9188923737345659e-06 0.012910000000000001 2.2390114313592552e-07 0.012920000000000001 1.3669709913509716e-06 0.012930000000000001 6.659599289971003e-06 0.012940000000000002 2.4732678959473202e-06 0.012950000000000001 -2.1343805419016474e-06 0.012960000000000001 -4.9175346733186536e-06 0.012970000000000001 -1.2233462408832959e-06 0.01298 3.9025769785647963e-06 0.012990000000000002 1.9896896389835879e-06 0.013000000000000001 -6.0376521479457809e-06 0.013010000000000001 5.9570951204346653e-06 0.01302 2.2918425748355373e-06 0.013030000000000002 4.6257064340246519e-06 0.013040000000000001 -3.7630429163015921e-06 0.013050000000000001 -6.5560813118200739e-06 0.01306 1.8414767705735848e-06 0.013070000000000002 7.5679252021798401e-06 0.013080000000000001 -1.7015915448667357e-06 0.013090000000000001 -3.8671970834154744e-06 0.013100000000000001 2.645246656245199e-06 0.013110000000000002 7.8634139402025569e-08 0.013120000000000001 2.6202277831685947e-06 0.013130000000000001 3.5997635496899715e-06 0.013140000000000001 -3.2986772349301901e-06 0.01315 2.8992821029200648e-07 0.013160000000000002 -5.4621707864395725e-06 0.013170000000000001 -1.2333266435615567e-06 0.013180000000000001 9.8496694949264046e-06 0.01319 2.7328179835483622e-07 0.013200000000000002 6.7183213247628891e-06 0.013210000000000001 -8.006130037683896e-07 0.013220000000000001 -6.1297580606050577e-06 0.01323 -5.3623322269840398e-06 0.013240000000000002 2.0625759540113292e-06 0.013250000000000001 2.7064422062063601e-06 0.013260000000000001 -8.6121418311608464e-06 0.013270000000000001 6.8023955599646447e-07 0.013280000000000002 -6.7319964130609141e-06 0.013290000000000001 -1.9397228172400584e-06 0.013300000000000001 5.8765631218493133e-06 0.013310000000000001 1.1957465975214915e-06 0.01332 -4.4076091861564318e-06 0.013330000000000002 -4.1562772048421738e-06 0.013340000000000001 -6.2270933590655656e-06 0.013350000000000001 2.076907662382346e-06 0.01336 2.7511763544775383e-07 0.013370000000000002 2.4388371300890376e-06 0.013380000000000001 4.069727877026571e-06 0.013390000000000001 -9.0302023869230503e-06 0.0134 -7.2703798778349357e-08 0.013410000000000002 4.0317276953464476e-06 0.013420000000000001 -4.5214018989649115e-06 0.013430000000000001 -2.22215632421117e-06 0.013440000000000001 5.3767204338557036e-06 0.013450000000000002 2.2836080844988424e-06 0.013460000000000001 -7.988970379418579e-07 0.013470000000000001 4.6480904174229853e-06 0.013480000000000001 9.5511012379380916e-07 0.01349 -2.207399067748863e-06 0.013500000000000002 1.8578752363110523e-06 0.013510000000000001 5.1143366647177786e-06 0.013520000000000001 -6.7430665568982531e-06 0.01353 6.7165500753883007e-06 0.013540000000000002 -2.7015595795679099e-06 0.013550000000000001 1.8572773057712016e-06 0.013560000000000001 1.9568243203301978e-06 0.01357 -1.4191178166703784e-06 0.013580000000000002 -7.190552262912335e-06 0.013590000000000001 -5.3172530520841589e-06 0.013600000000000001 2.6592875188376448e-06 0.013610000000000001 2.5593397539483778e-06 0.013620000000000002 -6.4102001453798748e-06 0.013630000000000001 8.1957569053709731e-07 0.013640000000000001 -8.814581877768767e-07 0.013650000000000001 -9.017302212830631e-06 0.01366 4.9809552607238127e-06 0.013670000000000002 -3.1155060746162972e-06 0.013680000000000001 2.9521268026339395e-06 0.013690000000000001 -1.8511062816008021e-06 0.0137 -6.0558994028229959e-06 0.013710000000000002 -4.6547654504758984e-06 0.013720000000000001 1.1095231331154424e-05 0.013730000000000001 9.3636359412417613e-06 0.01374 -7.5469771429818342e-06 0.013750000000000002 -2.5111666636965796e-06 0.013760000000000001 3.1031920696192168e-06 0.013770000000000001 7.3803714503383698e-07 0.013780000000000001 -1.5371598880872029e-06 0.013790000000000002 2.6660353767228431e-06 0.013800000000000002 -3.6726326298537972e-06 0.013810000000000001 2.5685469492773546e-06 0.013820000000000001 5.6441713596282929e-07 0.01383 -5.708657435569528e-06 0.013840000000000002 -6.7431799906082117e-06 0.013850000000000001 1.0601499815339597e-05 0.013860000000000001 -6.0505966409646217e-07 0.01387 3.9249657668548637e-07 0.013880000000000002 4.2034137611459087e-06 0.013890000000000001 -6.9223461621484867e-06 0.013900000000000001 -4.2627451109503102e-06 0.01391 1.2882143821308395e-05 0.013920000000000002 -2.5400907598259e-06 0.013930000000000001 -3.7465170934621044e-06 0.013940000000000001 -2.6390500963404531e-06 0.013950000000000001 -3.735411452054329e-06 0.013960000000000002 -6.9478875769809732e-06 0.013970000000000002 -1.1802168012664301e-07 0.013980000000000001 -6.9070069214713172e-06 0.013990000000000001 -2.5182166449490285e-06 0.014 -1.5652991756310473e-06 0.014010000000000002 1.033582436180277e-06 0.014020000000000001 1.1151091072777705e-06 0.014030000000000001 2.9016638758960487e-06 0.01404 -1.4446648824904594e-06 0.014050000000000002 2.5893210006769003e-06 0.014060000000000001 2.1502962430170059e-06 0.014070000000000001 3.6187765282325905e-06 0.014080000000000001 -1.4053153723173565e-06 0.014090000000000002 9.5035636962476051e-06 0.014100000000000001 -4.1757330385470074e-06 0.014110000000000001 -4.699063372604232e-06 0.014120000000000001 -7.5754886101524707e-06 0.014130000000000002 4.1016766835132311e-06 0.014140000000000002 7.2652572559324672e-07 0.014150000000000001 4.1087212022804532e-06 0.014160000000000001 -5.6764514409766093e-06 0.01417 -8.7095206607303781e-06 0.014180000000000002 3.6202806927342655e-06 0.014190000000000001 8.5413052623191941e-07 0.014200000000000001 4.1443984456657584e-06 0.01421 8.4417098627369741e-06 0.014220000000000002 -2.7889072053832607e-07 0.014230000000000001 6.1364457558742323e-07 0.014240000000000001 -1.0509488248719042e-05 0.014250000000000001 -1.3517166101190598e-05 0.014260000000000002 1.1734160681019014e-05 0.014270000000000001 -4.4283108797294049e-08 0.014280000000000001 -2.3307283038414318e-06 0.014290000000000001 3.9196631126853013e-06 0.014300000000000002 1.1213240543497477e-06 0.014310000000000002 9.2785874155396279e-06 0.014320000000000001 -3.9950050319645003e-06 0.014330000000000001 1.1654858114471425e-06 0.01434 -6.7058547248372422e-06 0.014350000000000002 -3.1956894770770593e-06 0.014360000000000001 5.8877620090216717e-06 0.014370000000000001 9.2483745966123686e-08 0.01438 -4.4809680647950592e-06 0.014390000000000002 4.7482099557940963e-06 0.014400000000000001 2.5313764762389097e-06 0.014410000000000001 1.3265373309719021e-06 0.014420000000000001 -8.0644265559307559e-07 0.014430000000000002 2.8578940981977955e-06 0.014440000000000001 1.1907586299499474e-05 0.014450000000000001 -1.3075422876533809e-05 0.014460000000000001 4.7397885346342456e-06 0.014470000000000002 -8.8456216726795469e-07 0.014480000000000002 -3.3186805218277685e-06 0.014490000000000001 7.8160028476621469e-06 0.014500000000000001 -1.4212172259417919e-07 0.01451 1.2616344892136321e-06 0.014520000000000002 5.432532626648029e-06 0.014530000000000001 -4.6341082416283739e-06 0.014540000000000001 9.9417126412599634e-06 0.01455 3.9981079003960236e-06 0.014560000000000002 1.4967230639605626e-06 0.014570000000000001 7.9926396934594241e-07 0.014580000000000001 7.1809257149064803e-06 0.014590000000000001 -1.0045417174744103e-06 0.014600000000000002 -5.342845577446758e-07 0.014610000000000001 -1.0704740889976087e-05 0.014620000000000001 7.8432532972699378e-06 0.014630000000000001 3.6646358963569895e-06 0.014640000000000002 5.5677395020258197e-06 0.014650000000000002 5.6915470825024108e-06 0.014660000000000001 4.267311601105203e-06 0.014670000000000001 1.8586152127749701e-06 0.01468 -5.4026182997173515e-06 0.014690000000000002 -4.2409255249834673e-06 0.014700000000000001 -3.1467921203247011e-06 0.014710000000000001 9.6984814021024961e-07 0.01472 -6.7009966523849045e-06 0.014730000000000002 -8.6217962230901452e-07 0.014740000000000001 -3.7499236279122995e-06 0.014750000000000001 -4.0395595413124822e-06 0.014760000000000001 -1.6592239265347631e-06 0.014770000000000002 -3.0751722511503475e-06 0.014780000000000001 -4.1732686617377429e-06 0.014790000000000001 8.8832375216580573e-06 0.014800000000000001 1.0178269322005117e-05 0.014810000000000002 -1.2862232758966677e-06 0.014820000000000002 -7.6022992997519562e-06 0.014830000000000001 6.8415064414137589e-07 0.014840000000000001 -5.2869735929112722e-06 0.01485 6.6729278835832971e-06 0.014860000000000002 7.253745337426599e-06 0.014870000000000001 4.1070590258627572e-06 0.014880000000000001 -6.3175160937609226e-06 0.01489 6.6511751952170648e-06 0.014900000000000002 2.5996079524880647e-06 0.014910000000000001 -4.7952494526399796e-06 0.014920000000000001 2.5234723374224022e-06 0.014930000000000001 3.3862390326285388e-07 0.014940000000000002 5.867065243674375e-06 0.014950000000000001 -1.4566651576339009e-06 0.014960000000000001 4.8150393533051677e-06 0.014970000000000001 -3.2557409517082818e-06 0.014980000000000002 7.3947076204388332e-06 0.014990000000000002 -1.6500888245614543e-06 0.015000000000000001 -2.533828045024105e-06 0.015010000000000001 -5.2264142805272816e-08 0.01502 4.4018771315322868e-06 0.015030000000000002 -2.7494315529772952e-06 0.015040000000000001 1.3622758513489758e-05 0.015050000000000001 -3.7546971837744743e-06 0.01506 -5.1446859312458362e-07 0.015070000000000002 5.0240562758522208e-06 0.015080000000000001 7.9967077296264014e-07 0.015090000000000001 -2.2965640686546754e-06 0.015100000000000001 2.0166626172139773e-07 0.015110000000000002 -8.0749785484039783e-06 0.015120000000000001 -1.4351471568579317e-06 0.015130000000000001 -3.2256684512277383e-06 0.015140000000000001 -1.5771659821325818e-06 0.015150000000000002 1.1512084472965799e-05 0.015160000000000002 2.2498668095182682e-06 0.015170000000000001 6.509420043338387e-06 0.015180000000000001 -2.2447374408285737e-06 0.01519 4.3524238198250001e-06 0.015200000000000002 5.6113971496584054e-06 0.015210000000000001 -1.1763807804700258e-06 0.015220000000000001 2.9096586721893532e-06 0.01523 -2.6145847107402532e-06 0.015240000000000002 3.921682534237201e-06 0.015250000000000001 -5.7560843310430046e-06 0.015260000000000001 -8.3476989994193643e-07 0.015270000000000001 4.0467176803273108e-06 0.015280000000000002 1.270617409960731e-05 0.015290000000000002 -2.5651780318050761e-06 0.015300000000000001 5.6272899582034171e-08 0.015310000000000001 2.6239396490162818e-06 0.015320000000000002 9.1942112718253541e-07 0.015330000000000002 1.3901265094964752e-06 0.015340000000000001 -5.4788689926786389e-07 0.015350000000000001 3.1124056611274951e-06 0.015360000000000002 -1.2415805974804516e-05 0.015370000000000002 2.6890217303448723e-06 0.015380000000000001 1.4988983380939945e-06 0.015390000000000001 -1.1763399478667691e-05 0.0154 6.5423486633187961e-06 0.015410000000000002 4.9591271965519102e-06 0.015420000000000001 1.9831492772255446e-06 0.015430000000000001 2.1733413100936968e-06 0.015440000000000001 9.2109715942216046e-06 0.015450000000000002 2.6753565525075449e-06 0.015460000000000002 1.1597353956199371e-06 0.015470000000000001 -3.2422656376044593e-06 0.015480000000000001 1.1964728696910955e-07 0.015490000000000002 2.9846983573917297e-06 0.015500000000000002 2.7733382274685156e-06 0.015510000000000001 1.8940741136010851e-06 0.015520000000000001 1.264624165628151e-06 0.015530000000000002 4.4891464250289906e-06 0.015540000000000002 1.8952501390082382e-06 0.015550000000000001 1.3872502713177152e-06 0.015560000000000001 -9.9918797196276495e-07 0.015570000000000001 -4.7742685536813973e-06 0.015580000000000002 -2.7221932514694571e-06 0.015590000000000001 -7.8151586120390291e-06 0.015600000000000001 2.3743418141279224e-06 0.015610000000000001 6.5713458984696395e-06 0.015620000000000002 -3.7716360279111554e-06 0.015630000000000002 1.1573516665498736e-06 0.015640000000000001 1.2692092131586325e-06 0.015650000000000001 2.1930920013387805e-06 0.01566 7.2738458567374718e-06 0.01567 -3.4457846704982851e-06 0.015680000000000003 2.0748323698898234e-06 0.015690000000000003 4.0667268108042222e-06 0.015700000000000002 -8.5953490859906268e-06 0.015710000000000002 4.6117764923657085e-06 0.015720000000000001 2.3023533395740122e-06 0.015730000000000001 -4.5734133068585809e-07 0.015740000000000001 -2.4452825846773452e-06 0.01575 1.6371657523583212e-06 0.01576 -8.0051361474836513e-06 0.015770000000000003 1.6974258921671568e-06 0.015780000000000002 -3.5261681201109251e-06 0.015790000000000002 1.465825816429029e-06 0.015800000000000002 3.5898617047860768e-06 0.015810000000000001 -2.9227026264298523e-06 0.015820000000000001 -2.3595959609524292e-06 0.01583 3.9361426394745441e-09 0.01584 3.6778381693045567e-06 0.015850000000000003 7.8282391013981692e-06 0.015860000000000003 3.0325914740306005e-06 0.015870000000000002 7.2850359499750192e-06 0.015880000000000002 -7.0307902694916466e-06 0.015890000000000001 6.2010200889961705e-06 0.015900000000000001 5.4202877495873048e-07 0.015910000000000001 -9.3422716271397969e-06 0.01592 -1.223907928614327e-06 0.01593 1.00281689952498e-05 0.015940000000000003 1.9380865786279144e-06 0.015950000000000002 -5.7928051992518006e-06 0.015960000000000002 7.66235549765165e-08 0.015970000000000002 1.9858026679127239e-06 0.015980000000000001 1.5126302045937197e-06 0.015990000000000001 7.9646251975672247e-06 0.016 -1.3606387951773183e-05 0.01601 -6.7303082193442986e-07 0.016020000000000003 7.5026738866174367e-06 0.016030000000000003 -5.2088810229389278e-06 0.016040000000000002 1.6500650719396733e-06 0.016050000000000002 1.0413740732883939e-05 0.016060000000000001 -2.3994699909786109e-06 0.016070000000000001 -3.3869326670576954e-06 0.016080000000000001 2.0722722504847002e-06 0.01609 1.0981448118834868e-05 0.0161 6.7111028897965479e-06 0.016110000000000003 -5.6123495215950237e-06 0.016120000000000002 5.5463965941624839e-06 0.016130000000000002 3.2070787730220082e-06 0.016140000000000002 2.1296249884730386e-06 0.016150000000000001 -1.7586751433731375e-07 0.016160000000000001 3.4923090746716159e-06 0.01617 2.4475622877540158e-06 0.01618 1.4109931137094395e-05 0.016190000000000003 7.3906996240591192e-06 0.016200000000000003 2.4593225349840754e-06 0.016210000000000002 -5.9938204699019001e-06 0.016220000000000002 -4.8760410140111566e-06 0.016230000000000001 -4.892393395332085e-06 0.016240000000000001 1.8238966160299786e-06 0.016250000000000001 -1.53898427141741e-06 0.01626 -6.0751985368814916e-06 0.01627 -8.6377026106905337e-06 0.016280000000000003 1.8536428398898884e-06 0.016290000000000002 -2.4863602134628218e-06 0.016300000000000002 -8.4250947667396502e-06 0.016310000000000002 -7.8810560304448064e-06 0.016320000000000001 -3.8248257001708828e-06 0.016330000000000001 -4.858480922587145e-07 0.01634 -5.2627516972694414e-06 0.01635 3.2907123037444281e-07 0.016360000000000003 6.3859475811332949e-06 0.016370000000000003 3.1966637008619351e-06 0.016380000000000002 -1.481677941470544e-06 0.016390000000000002 -3.3936725396034091e-06 0.016400000000000001 -4.1680677692933244e-06 0.016410000000000001 5.8161003202887095e-07 0.016420000000000001 7.3887317484228427e-06 0.01643 9.6240138344916608e-06 0.01644 -2.2777480612165071e-06 0.016450000000000003 -3.4736469283585e-06 0.016460000000000002 -5.8798063371512356e-06 0.016470000000000002 1.1028261475208435e-06 0.016480000000000002 -6.3853542283173141e-06 0.016490000000000001 1.7844106948949353e-06 0.016500000000000001 1.3424594156472517e-07 0.01651 1.9141623348448926e-07 0.01652 1.9511241110089156e-06 0.016530000000000003 -8.8526402636245066e-07 0.016540000000000003 -4.1587544519188511e-06 0.016550000000000002 -1.706129235338429e-06 0.016560000000000002 -1.1860217831831928e-06 0.016570000000000001 4.4729372164869281e-08 0.016580000000000001 -6.6058880735466445e-06 0.016590000000000001 -4.5698674695798497e-06 0.0166 1.5999648087234953e-06 0.01661 -9.6642650255341297e-07 0.016620000000000003 5.2555545197961542e-06 0.016630000000000002 -6.2284782633676997e-06 0.016640000000000002 -1.9355636690672734e-06 0.016650000000000002 -3.0875499186467877e-06 0.016660000000000001 6.4363884784728636e-06 0.016670000000000001 -3.9999135749277287e-07 0.01668 3.974714866075838e-06 0.01669 8.3729543746040768e-06 0.016700000000000003 -2.102829560527786e-07 0.016710000000000003 -1.999496907853597e-06 0.016720000000000002 7.5911188184309258e-06 0.016730000000000002 -3.6479419366369657e-06 0.016740000000000001 4.0640722557991235e-06 0.016750000000000001 3.7955439667863596e-07 0.016760000000000001 -5.9904142774844887e-06 0.01677 -1.5669509852093626e-06 0.01678 5.8462154410417507e-08 0.016790000000000003 -3.4929094583903368e-06 0.016800000000000002 2.1104175017327881e-06 0.016810000000000002 2.9331566628680506e-06 0.016820000000000002 5.9080848126353211e-06 0.016830000000000001 -6.6353446313008918e-07 0.016840000000000001 2.332889256425926e-06 0.01685 2.5609129685045338e-06 0.01686 8.0214840970695749e-07 0.016870000000000003 -7.2347789441693249e-06 0.016880000000000003 3.8576341103052508e-06 0.016890000000000002 -1.1189900935001259e-06 0.016900000000000002 -4.1069917569052944e-06 0.016910000000000001 -1.5215665832795122e-06 0.016920000000000001 5.6023858473442398e-07 0.016930000000000001 1.0123292732252388e-06 0.01694 1.4894410835378881e-06 0.01695 7.9944343640278835e-07 0.016960000000000003 -1.0161660238418401e-05 0.016970000000000002 4.9456540965332863e-06 0.016980000000000002 1.2567048524722594e-05 0.016990000000000002 -1.176687935523163e-06 0.017000000000000001 -5.762663334347852e-06 0.017010000000000001 8.2427713589877698e-06 0.01702 4.3661930950064415e-06 0.01703 2.1473935391789009e-06 0.017040000000000003 -8.410235792755659e-06 0.017050000000000003 -1.0218276400260571e-06 0.017060000000000002 -4.7885213210112093e-06 0.017070000000000002 -4.8092011351978932e-06 0.017080000000000001 -9.660529889812848e-07 0.017090000000000001 -3.0950961860378663e-06 0.017100000000000001 -7.5885586441386838e-07 0.01711 -1.4413814113717284e-05 0.01712 -3.8193518869682988e-06 0.017130000000000003 2.7581861067745404e-06 0.017140000000000002 4.2497852578895385e-06 0.017150000000000002 1.1951093823796213e-06 0.017160000000000002 1.0833740378153482e-06 0.017170000000000001 3.7022978748120063e-06 0.017180000000000001 2.2617756318824473e-06 0.01719 -3.4441445531398782e-07 0.0172 2.5852948709550858e-06 0.017210000000000003 -5.2874799729059911e-06 0.017220000000000003 -3.7639945303836921e-06 0.017230000000000002 1.0508493688292341e-06 0.017240000000000002 -1.4140070996463107e-05 0.017250000000000001 -2.159452899151445e-06 0.017260000000000001 -1.8562871427458259e-06 0.017270000000000001 -4.5427782989110633e-06 0.01728 9.5910320334200049e-07 0.01729 3.3519373773401604e-06 0.017300000000000003 7.0426306358687644e-07 0.017310000000000002 -1.0921816961966101e-06 0.017320000000000002 -2.4995492957563485e-06 0.017330000000000002 6.8591347517194127e-06 0.017340000000000001 1.432487903921728e-06 0.017350000000000001 7.0421004298962837e-07 0.01736 -1.1236626164453757e-05 0.01737 -9.8399532250585146e-06 0.017380000000000003 -6.9862902620779092e-06 0.017390000000000003 1.1650927274300344e-06 0.017400000000000002 9.6498089652875174e-06 0.017410000000000002 -2.4715438181342728e-07 0.017420000000000001 1.3655287679018289e-05 0.017430000000000001 9.4659395088173707e-06 0.017440000000000001 3.050144672162922e-07 0.01745 -1.7232601879928676e-06 0.01746 1.6553267105916895e-05 0.017470000000000003 3.3358853214277225e-06 0.017480000000000002 1.3024593494600698e-06 0.017490000000000002 -1.4006703504124441e-06 0.017500000000000002 7.6940649782102518e-07 0.017510000000000001 3.0441616801512643e-06 0.017520000000000001 -8.4384584352302912e-06 0.01753 -6.3497888300609136e-06 0.01754 2.2455565998917215e-06 0.017550000000000003 -3.962441775289487e-06 0.017560000000000003 5.3790939984753701e-07 0.017570000000000002 1.5958117360314968e-06 0.017580000000000002 -1.3556326461202056e-05 0.017590000000000001 -7.2929047456026036e-06 0.017600000000000001 -1.453176021732069e-06 0.017610000000000001 -6.0986134302116449e-06 0.01762 -4.7416084204616932e-06 0.01763 1.5363613296271235e-06 0.017640000000000003 -5.2405528995810525e-06 0.017650000000000002 -8.4606703672055638e-06 0.017660000000000002 -6.212047743474541e-06 0.017670000000000002 1.0546476411020359e-06 0.017680000000000001 1.0964283855429249e-05 0.017690000000000001 8.0214167972882892e-06 0.0177 1.6501221408093598e-06 0.01771 -4.1768349853461507e-06 0.017720000000000003 -1.0152485056962685e-05 0.017730000000000003 -1.946981297047668e-06 0.017740000000000002 1.3381984576638813e-06 0.017750000000000002 1.8094114168823867e-06 0.017760000000000001 1.0083044490096228e-06 0.017770000000000001 1.3166726324225473e-06 0.017780000000000001 -5.1369952162377923e-06 0.01779 8.967331300900065e-06 0.0178 6.4490002466369254e-06 0.017810000000000003 -3.1941900216256621e-06 0.017820000000000003 4.1746091479295527e-06 0.017830000000000002 4.0235928487915728e-06 0.017840000000000002 3.2215292174540232e-06 0.017850000000000001 3.5627869744488669e-06 0.017860000000000001 -7.271206860585137e-06 0.01787 -4.2578158921813859e-06 0.01788 -1.9801126673751007e-06 0.017890000000000003 -1.1794376787283852e-05 0.017900000000000003 3.6907643889138588e-07 0.017910000000000002 7.3675591867849594e-06 0.017920000000000002 3.2783113893579821e-06 0.017930000000000001 -6.3242233905249445e-07 0.017940000000000001 -3.4159698342985631e-06 0.017950000000000001 -9.1033149117537231e-06 0.01796 -2.9179923157435959e-06 0.01797 -1.1124886585381163e-06 0.017980000000000003 4.2628111478584856e-06 0.017990000000000003 -3.3568639642146645e-06 0.018000000000000002 4.0412749129305608e-06 0.018010000000000002 -9.3363748806277747e-06 0.018020000000000001 -3.6101580018307399e-07 0.018030000000000001 5.3658562412489783e-06 0.01804 -1.2644761530107435e-06 0.01805 4.6881890557890748e-06 0.018060000000000003 -1.0431860555857679e-06 0.018070000000000003 5.2726524129813403e-06 0.018080000000000002 -2.6332659447680615e-06 0.018090000000000002 3.2211299651127677e-06 0.018100000000000002 3.2489601997047275e-06 0.018110000000000001 1.9914429726499531e-06 0.018120000000000001 7.3043756492555947e-06 0.01813 3.5581274937143969e-06 0.01814 -3.1293507110020681e-06 0.018150000000000003 -3.8995373582707184e-06 0.018160000000000003 4.8524517400255096e-06 0.018170000000000002 1.6248875978647748e-06 0.018180000000000002 3.8671908461686841e-06 0.018190000000000001 -3.2556085974849777e-07 0.018200000000000001 5.2966148625032269e-08 0.01821 -7.7336713208048345e-07 0.01822 -6.0797760310708287e-06 0.018230000000000003 5.5517187697007033e-06 0.018240000000000003 5.2076860682169971e-06 0.018250000000000002 1.3148744243995318e-06 0.018260000000000002 -7.7689302029341741e-07 0.018270000000000002 1.2896914971558591e-05 0.018280000000000001 -2.5823380997339264e-09 0.018290000000000001 6.8757924536605933e-06 0.0183 -3.5558228169116748e-06 0.01831 9.2270384897895534e-06 0.018320000000000003 2.8976396307017257e-06 0.018330000000000003 -5.7557694953860742e-06 0.018340000000000002 1.0908428199049468e-05 0.018350000000000002 -5.3826880515442696e-06 0.018360000000000001 -9.6587417138988942e-07 0.018370000000000001 -8.1634461893993856e-06 0.018380000000000001 -1.3104531693533602e-06 0.01839 -1.3414568171529574e-06 0.018400000000000003 -4.4331687189982889e-06 0.018410000000000003 3.6618392699343695e-06 0.018420000000000002 -1.7205254982079017e-06 0.018430000000000002 4.2963504358679156e-06 0.018440000000000002 -1.0591779646497847e-06 0.018450000000000001 -1.191697282860769e-05 0.018460000000000001 2.0100597314474242e-06 0.01847 2.7102823169951785e-06 0.01848 -2.7950961234230122e-06 0.018490000000000003 -3.2939356549306917e-06 0.018500000000000003 2.9051602410956603e-06 0.018510000000000002 2.1839985844743496e-06 0.018520000000000002 -1.7010166406073913e-06 0.018530000000000001 8.7637153676545947e-06 0.018540000000000001 6.1570278016098561e-06 0.018550000000000001 -4.5226919520450778e-06 0.01856 1.085506347587273e-06 0.018570000000000003 -1.2365653207198632e-05 0.018580000000000003 3.6998735418351067e-06 0.018590000000000002 1.9937991729737404e-06 0.018600000000000002 -5.1420292398988984e-06 0.018610000000000002 -5.2250701891308297e-06 0.018620000000000001 1.6413183456533701e-06 0.018630000000000001 3.6180974402476154e-06 0.01864 3.1220363847642848e-06 0.01865 5.2662008810735239e-06 0.018660000000000003 -1.0981954545882571e-06 0.018670000000000003 -4.7913417741318266e-06 0.018680000000000002 -1.9292702054785598e-06 0.018690000000000002 5.4973827474023901e-06 0.018700000000000001 4.2271957886253893e-06 0.018710000000000001 2.9279364357396695e-06 0.018720000000000001 -5.1790421022545837e-06 0.01873 5.1725649319451069e-07 0.018740000000000003 2.7856802826249834e-06 0.018750000000000003 -8.7037670583108841e-06 0.018760000000000002 -4.69549100289525e-07 0.018770000000000002 -8.6223332399820572e-07 0.018780000000000002 4.6532783928621698e-06 0.018790000000000001 9.3637334115706321e-07 0.018800000000000001 5.7993245597652633e-06 0.01881 -4.0064367747425812e-06 0.01882 3.7404285593258262e-06 0.018830000000000003 -1.649073006902421e-06 0.018840000000000003 -2.5125999921927749e-07 0.018850000000000002 -1.760643073926631e-06 0.018860000000000002 1.1954729275181273e-06 0.018870000000000001 -2.4587690959886271e-06 0.018880000000000001 -5.5701673996701001e-06 0.018890000000000001 5.3708082460023344e-06 0.0189 2.7363870798342042e-06 0.018910000000000003 3.6803594985604235e-06 0.018920000000000003 -4.9574831193520886e-06 0.018930000000000002 -1.9498791320522762e-06 0.018940000000000002 2.8736612508582274e-07 0.018950000000000002 -1.9345377687935594e-06 0.018960000000000001 2.3867123109643842e-06 0.018970000000000001 9.1323571105325703e-07 0.01898 3.2704588443631053e-06 0.01899 -9.4711553597841615e-06 0.019000000000000003 4.1681542023892598e-06 0.019010000000000003 -4.0106347750952487e-07 0.019020000000000002 -4.0196232187395315e-06 0.019030000000000002 -5.3577657492784137e-06 0.019040000000000001 2.6153372780656418e-06 0.019050000000000001 -4.0270121984554193e-06 0.019060000000000001 -3.5277269584498019e-06 0.01907 6.9824236179566194e-06 0.019080000000000003 2.911565007124408e-06 0.019090000000000003 2.1178904403892224e-06 0.019100000000000002 2.4864409077693235e-06 0.019110000000000002 -2.0704910918157108e-06 0.019120000000000002 -7.6721940538982153e-06 0.019130000000000001 -1.6035042440896992e-06 0.019140000000000001 -1.4749412834580818e-06 0.01915 7.9088190655233262e-06 0.01916 1.6510239970657294e-06 0.019170000000000003 2.6284314889592123e-06 0.019180000000000003 -5.266924770360162e-06 0.019190000000000002 6.1175909846805706e-06 0.019200000000000002 2.4000149761629429e-06 0.019210000000000001 -1.7232548513132727e-06 0.019220000000000001 -2.3017181124996736e-06 0.019230000000000001 -7.2118153061870293e-07 0.01924 3.0875178955704465e-06 0.019250000000000003 1.3240036243891054e-05 0.019260000000000003 3.3746220609404071e-06 0.019270000000000002 7.9384270421108774e-07 0.019280000000000002 -1.3909093471341722e-06 0.019290000000000002 1.2003557097459109e-07 0.019300000000000001 -4.7921551536716809e-06 0.019310000000000001 -7.1643116085934761e-06 0.01932 -3.6198440070260786e-06 0.01933 2.9463613361937793e-06 0.019340000000000003 1.1031059462182845e-05 0.019350000000000003 1.541165476169194e-07 0.019360000000000002 -1.1210777429362678e-05 0.019370000000000002 6.3727459336363882e-06 0.019380000000000001 6.5208211645693425e-07 0.019390000000000001 -4.5244029886840364e-06 0.019400000000000001 -3.3787249606281845e-06 0.01941 4.6086748528341566e-06 0.019420000000000003 -5.8052660723924955e-06 0.019430000000000003 -6.5306501415313127e-06 0.019440000000000002 -2.5692713378523792e-06 0.019450000000000002 7.215757655761878e-06 0.019460000000000002 7.6434021000493506e-06 0.019470000000000001 -1.4465582063551726e-06 0.019480000000000001 -1.9895870458709725e-06 0.01949 4.3860945331144255e-06 0.0195 2.1031198986130949e-06 0.019510000000000003 5.9707042098371258e-06 0.019520000000000003 3.1260438036601783e-06 0.019530000000000002 -1.6550253195815001e-06 0.019540000000000002 -6.5562713385150369e-06 0.019550000000000001 4.8236107253723867e-06 0.019560000000000001 2.1316391051041182e-07 0.019570000000000001 7.9726436653297635e-06 0.01958 -1.8081435291216707e-06 0.019590000000000003 -4.0542293869906378e-06 0.019600000000000003 -1.4550855928447888e-06 0.019610000000000002 -2.1612077942746685e-06 0.019620000000000002 -5.8954936758592528e-06 0.019630000000000002 -4.6452787277411443e-06 0.019640000000000001 4.4478674756393976e-08 0.019650000000000001 5.8920995979693039e-06 0.01966 -3.6984715019615269e-06 0.01967 3.5204079099803036e-07 0.019680000000000003 -1.3395013573840543e-06 0.019690000000000003 1.4666916546248197e-06 0.019700000000000002 5.0020543280615143e-06 0.019710000000000002 -2.865334708025176e-06 0.019720000000000001 7.3185350051487205e-06 0.019730000000000001 -5.1676743116075466e-07 0.019740000000000001 2.369705405499998e-06 0.01975 -1.4729936367928433e-06 0.019760000000000003 1.2040160598128534e-05 0.019770000000000003 7.1843402378663505e-06 0.019780000000000002 -6.860392569005565e-06 0.019790000000000002 -4.8879893231190614e-06 0.019800000000000002 7.5095640701678518e-06 0.019810000000000001 9.4743291486601312e-06 0.019820000000000001 -3.4992324549363937e-06 0.01983 -1.1536573307858663e-05 0.01984 -2.2950451821004164e-06 0.019850000000000003 5.474451799308687e-07 0.019860000000000003 1.7338560879547083e-06 0.019870000000000002 -1.0448908661669222e-05 0.019880000000000002 6.6255193904450952e-06 0.019890000000000001 -9.5424223949265389e-06 0.019900000000000001 1.4657939481319627e-05 0.019910000000000001 -1.2957407116716253e-06 0.01992 -6.5994885216388224e-06 0.019930000000000003 -5.7951075637607063e-07 0.019940000000000003 5.8790603040710357e-06 0.019950000000000002 1.1533488110346214e-06 0.019960000000000002 -1.1512151393078515e-05 0.019970000000000002 4.2950032593998822e-06 0.019980000000000001 -4.963860292138381e-06 0.019990000000000001 5.5626391883910905e-06 0.02 -7.3262440178320135e-06 0.02001 1.3904729825895994e-06 0.020020000000000003 2.3097413227581443e-06 0.020030000000000003 -2.6911727206807606e-07 0.020040000000000002 -1.1884421234550038e-06 0.020050000000000002 -4.7350566235304718e-06 0.020060000000000001 -6.9919406600028935e-07 0.020070000000000001 8.3428644042546459e-07 0.020080000000000001 -6.8767289667238777e-06 0.02009 7.2042012682448234e-06 0.020100000000000003 6.9830548826940532e-08 0.020110000000000003 1.0146344131168049e-07 0.020120000000000002 5.0290012881700843e-06 0.020130000000000002 -7.307063212584341e-07 0.020140000000000002 3.8891867193300775e-06 0.020150000000000001 -1.9447016227251952e-06 0.020160000000000001 4.3602380747457292e-07 0.02017 -2.1109899518675721e-06 0.02018 -3.8160909530730781e-06 0.020190000000000003 -7.7581807852150597e-06 0.020200000000000003 1.8669967537851371e-06 0.020210000000000002 -8.2936998878062356e-06 0.020220000000000002 -8.9766145784731654e-07 0.020230000000000001 -5.710058866224475e-06 0.020240000000000001 -6.6128053928093452e-07 0.020250000000000001 1.6003408471692846e-06 0.02026 -2.6490179317281382e-07 0.020270000000000003 -1.7348920598796687e-06 0.020280000000000003 1.1170894498670211e-05 0.020290000000000002 -1.3294539254195193e-06 0.020300000000000002 6.0979470843004568e-08 0.020310000000000002 -2.777672161075996e-06 0.020320000000000001 -9.7638343535458475e-07 0.020330000000000001 1.8384712916184503e-07 0.02034 -6.7162304869174934e-06 0.02035 5.9914850423225577e-06 0.020360000000000003 -7.7408754272384421e-06 0.020370000000000003 -6.5429343287383108e-06 0.020380000000000002 -4.7703664200857306e-06 0.020390000000000002 -3.073769969176658e-06 0.020400000000000001 7.6091092540782595e-06 0.020410000000000001 -3.7882743797236644e-06 0.020420000000000001 2.9604277540974542e-07 0.02043 6.2416063210987065e-06 0.020440000000000003 -3.4669334912912534e-06 0.020450000000000003 2.3991227877524395e-06 0.020460000000000002 -1.1742274222730591e-05 0.020470000000000002 -4.3306611224135766e-06 0.020480000000000002 5.5826545554450526e-06 0.020490000000000001 -2.1123336257382752e-06 0.020500000000000001 8.7035629072960094e-07 0.02051 -4.2636076101616482e-06 0.02052 -1.9614601135388733e-06 0.020530000000000003 7.8055021239665402e-06 0.020540000000000003 -1.1724446904531697e-06 0.020550000000000002 3.1741857341827492e-06 0.020560000000000002 -1.645301681025498e-06 0.020570000000000001 6.9779037654348012e-06 0.020580000000000001 -3.9519100028972526e-06 0.020590000000000001 3.6195905503141165e-06 0.0206 -4.930190031564456e-07 0.020610000000000003 8.1023742610423976e-06 0.020620000000000003 -1.2032798843812964e-07 0.020630000000000003 4.3706472498059433e-07 0.020640000000000002 6.5156747108386864e-06 0.020650000000000002 -1.1222254857465166e-05 0.020660000000000001 -8.0844031253285584e-06 0.020670000000000001 -9.6053658452928812e-06 0.02068 -1.0685993828700414e-06 0.02069 -9.6110568251864681e-06 0.020700000000000003 -7.6948084592713232e-06 0.020710000000000003 -3.5913207174139208e-06 0.020720000000000002 3.0285103051684485e-06 0.020730000000000002 -4.0486521097024441e-06 0.020740000000000001 4.282056510663453e-06 0.020750000000000001 9.6387450150672773e-06 0.020760000000000001 4.4870243763637819e-06 0.02077 4.1524104861054391e-06 0.020780000000000003 -9.6845533905980697e-06 0.020790000000000003 -2.630568292180349e-06 0.020800000000000003 -1.3649106567776054e-06 0.020810000000000002 9.0848040779880399e-07 0.020820000000000002 3.2917203983905667e-06 0.020830000000000001 7.2382971652710552e-06 0.020840000000000001 1.8929735126154979e-06 0.02085 -9.7850058549022171e-08 0.02086 3.5882832394661188e-08 0.020870000000000003 -3.2133058265511664e-06 0.020880000000000003 -2.8851693141577876e-06 0.020890000000000002 1.0520312198964183e-06 0.020900000000000002 1.3918581252195526e-05 0.020910000000000002 7.8390773931724717e-06 0.020920000000000001 4.9634537883308439e-06 0.020930000000000001 1.0475920650256223e-05 0.02094 1.1144004586381852e-07 0.020950000000000003 -2.1831057648593179e-06 0.020960000000000003 -4.3667277780265691e-07 0.020970000000000003 -3.693817845134779e-06 0.020980000000000002 -3.6594813602894684e-06 0.020990000000000002 3.7479017394247813e-06 0.021000000000000001 -7.8099435376817788e-06 0.021010000000000001 -4.7339738469135129e-07 0.02102 6.5895873184079687e-06 0.02103 -6.3660682980347757e-06 0.021040000000000003 1.5832578155068195e-06 0.021050000000000003 6.4481859294322024e-06 0.021060000000000002 5.1909538051188192e-06 0.021070000000000002 -1.0560156364642483e-06 0.021080000000000002 -4.0417715764551813e-06 0.021090000000000001 -3.1509943959456594e-06 0.021100000000000001 -4.8298882384042787e-06 0.02111 2.0785857481441361e-06 0.021120000000000003 -2.5562000047906398e-06 0.021130000000000003 -3.4328898114465865e-06 0.021140000000000003 -1.3740505208708198e-07 0.021150000000000002 -6.7236135108751099e-07 0.021160000000000002 -3.1457086532075266e-06 0.021170000000000001 -5.3254850743142119e-06 0.021180000000000001 -5.1732915840444286e-06 0.021190000000000001 -1.7507806959385108e-07 0.0212 -1.3947885906740729e-06 0.021210000000000003 7.2527795696031223e-06 0.021220000000000003 -1.0128300347682358e-05 0.021230000000000002 2.526053681597812e-06 0.021240000000000002 6.1570574064768564e-06 0.021250000000000002 5.0027174008305971e-06 0.021260000000000001 4.5621637010958329e-06 0.021270000000000001 -4.6383176515199409e-06 0.02128 4.1159745981014445e-06 0.021290000000000003 4.3642310025504521e-06 0.021300000000000003 -1.2529162129545827e-05 0.021310000000000003 -1.5841142317594023e-07 0.021320000000000002 -2.1638437331999299e-06 0.021330000000000002 -8.5806977203417321e-06 0.021340000000000001 4.8718640094617364e-06 0.021350000000000001 9.6441312535597036e-06 0.021360000000000001 9.6456352769397323e-07 0.02137 -1.6789932868413567e-06 0.021380000000000003 -7.7279167680002857e-07 0.021390000000000003 3.892645098069625e-06 0.021400000000000002 1.2051723286609272e-06 0.021410000000000002 4.4580096763908891e-06 0.021420000000000002 1.4620284713676288e-06 0.021430000000000001 -4.244207351995689e-06 0.021440000000000001 8.9226370730583496e-06 0.02145 -8.3128636578679761e-06 0.021460000000000003 -1.2795377101209685e-07 0.021470000000000003 5.2579456135388886e-06 0.021480000000000003 -8.0642010747402527e-07 0.021490000000000002 2.7179442626605295e-06 0.021500000000000002 1.0926657843911809e-06 0.021510000000000001 2.9870484790953535e-07 0.021520000000000001 2.7662597792319316e-06 0.021530000000000001 -3.1368927279449025e-06 0.02154 1.3807134931592817e-06 0.021550000000000003 -3.4350881543845034e-06 0.021560000000000003 3.2886877025846552e-06 0.021570000000000002 -4.9153970751652841e-06 0.021580000000000002 -1.0284383354481081e-05 0.021590000000000002 -2.8356801484998301e-06 0.021600000000000001 4.4117732624159767e-06 0.021610000000000001 -3.6686895922954829e-06 0.02162 5.2699688034720421e-06 0.021630000000000003 -9.4160374044283436e-07 0.021640000000000003 -1.0774897911027909e-05 0.021650000000000003 -1.3154862696875263e-06 0.021660000000000002 2.4545035864767271e-06 0.021670000000000002 1.7162481474551604e-06 0.021680000000000001 -1.4998045957550842e-06 0.021690000000000001 9.8657716767332008e-06 0.021700000000000001 -8.8207649379754648e-06 0.02171 -1.4775894082145015e-06 0.021720000000000003 3.9475680893986788e-06 0.021730000000000003 1.4988022695206043e-05 0.021740000000000002 -1.7586173337157177e-06 0.021750000000000002 3.9055298582334179e-07 0.021760000000000002 1.9746739807513241e-06 0.021770000000000001 -1.3600585466582586e-06 0.021780000000000001 -4.1794731379034596e-06 0.02179 3.7998503919231751e-07 0.021800000000000003 4.1248136047956482e-06 0.021810000000000003 -6.3294417967967094e-06 0.021820000000000003 6.9506039784688893e-06 0.021830000000000002 -3.9914413713046196e-07 0.021840000000000002 5.3229920682424692e-06 0.021850000000000001 -1.0848966783518337e-05 0.021860000000000001 -3.674880184952208e-06 0.021870000000000001 -1.4253903703879313e-07 0.02188 -1.8391173313721627e-06 0.021890000000000003 -1.5698117518256195e-06 0.021900000000000003 8.609632369470075e-06 0.021910000000000002 7.9818649292772533e-06 0.021920000000000002 2.9576579806917105e-06 0.021930000000000002 2.5402144528355689e-06 0.021940000000000001 2.9324770887939809e-06 0.021950000000000001 4.1490483618479825e-06 0.02196 2.8005552273350855e-07 0.021970000000000003 -9.1972819330129736e-06 0.021980000000000003 4.6019799883859243e-06 0.021990000000000003 5.6523843543010299e-07 0.022000000000000002 7.0524765314777321e-08 0.022010000000000002 9.6641758236890086e-06 0.022020000000000001 6.6523261441233843e-07 0.022030000000000001 5.6928106095285407e-06 0.022040000000000001 6.5494550774188435e-06 0.02205 3.8659259869383886e-06 0.022060000000000003 -1.1028677204284139e-06 0.022070000000000003 -7.184366702560082e-07 0.022080000000000002 -4.4043491334960832e-06 0.022090000000000002 -9.7817200744779312e-06 0.022100000000000002 -1.7223637183461429e-06 0.022110000000000001 7.1114359158364181e-06 0.022120000000000001 -2.1547871306663098e-06 0.02213 -3.0645496827386541e-08 0.022140000000000003 -1.2739050504241027e-06 0.022150000000000003 -7.3899412282690649e-07 0.022160000000000003 3.0178742669014048e-06 0.022170000000000002 4.3067309124797096e-06 0.022180000000000002 6.3448991630217896e-06 0.022190000000000001 -5.7808090441191513e-06 0.022200000000000001 8.3118940113505255e-06 0.022210000000000001 1.0651785339397107e-05 0.02222 -5.5530611085018986e-06 0.022230000000000003 -2.7987441038522354e-06 0.022240000000000003 -2.3693164607970787e-06 0.022250000000000002 6.471576472550554e-07 0.022260000000000002 -7.303209194408136e-06 0.022270000000000002 -4.2989519197272689e-06 0.022280000000000001 -7.8194545629289448e-06 0.022290000000000001 4.9662294272343801e-06 0.0223 4.9428884857416478e-06 0.022310000000000003 7.8933356139709714e-06 0.022320000000000003 -4.0281726216491113e-06 0.022330000000000003 -7.885760766150063e-06 0.022340000000000002 -1.6524144234343595e-06 0.022350000000000002 -1.7560535348492139e-06 0.022360000000000001 -3.0270815692741055e-06 0.022370000000000001 1.33889349420215e-06 0.022380000000000001 7.3847733818050617e-07 0.02239 7.9692467360976273e-06 0.022400000000000003 -5.5490245678594492e-06 0.022410000000000003 -2.1152742682540804e-06 0.022420000000000002 -1.1463541030312216e-05 0.022430000000000002 1.2103398546452228e-05 0.022440000000000002 -4.01898807405654e-06 0.022450000000000001 -6.2631010881209664e-06 0.022460000000000001 3.3350218682271662e-06 0.02247 -4.595621610137381e-06 0.022480000000000003 2.7047141061622647e-06 0.022490000000000003 -4.9896889811630399e-06 0.022500000000000003 -6.6692982541837651e-06 0.022510000000000002 1.2436898685066743e-06 0.022520000000000002 -8.2402995662371362e-06 0.022530000000000001 5.0004488213533097e-06 0.022540000000000001 -4.0860890492861084e-06 0.022550000000000001 -5.5113577627070093e-06 0.02256 -3.566253307983236e-06 0.022570000000000003 1.5200436554739256e-06 0.022580000000000003 2.9572909322463521e-06 0.022590000000000002 6.7282300336620014e-07 0.022600000000000002 5.2356221403401877e-06 0.022610000000000002 -9.8259600217210344e-06 0.022620000000000001 6.241403765254176e-06 0.022630000000000001 8.2557513479797565e-07 0.02264 9.2310436829989039e-07 0.022650000000000003 -6.6395298214446095e-06 0.022660000000000003 -3.6278369254744289e-06 0.022670000000000003 4.2611526868978842e-06 0.022680000000000002 -9.441707445476337e-06 0.022690000000000002 1.0574632444973503e-05 0.022700000000000001 -1.221295566649388e-06 0.022710000000000001 4.6017203528948679e-06 0.022720000000000001 -1.6938250332724922e-06 0.02273 -1.8014775147038058e-06 0.022740000000000003 5.1960324742207611e-06 0.022750000000000003 3.3647659913076381e-06 0.022760000000000002 8.0419599691858992e-07 0.022770000000000002 -5.9832759938760366e-06 0.022780000000000002 -6.0715742181714673e-06 0.022790000000000001 -9.797689444593101e-07 0.022800000000000001 -6.9823866751154179e-06 0.02281 -1.6535066427667911e-07 0.022820000000000003 1.7160776916984134e-06 0.022830000000000003 3.2307882163174464e-06 0.022840000000000003 -5.599251207336562e-07 0.022850000000000002 -2.4932346745867117e-06 0.022860000000000002 6.9214628213554843e-07 0.022870000000000001 2.8140862818701751e-06 0.022880000000000001 -9.2631542433829053e-06 0.022890000000000001 -8.2964776518131409e-07 0.0229 -1.0407891658177921e-06 0.022910000000000003 -3.6767617977603685e-07 0.022920000000000003 -5.5066726876392349e-07 0.022930000000000002 2.1135604603495609e-06 0.022940000000000002 -1.9041838841092921e-06 0.022950000000000002 -5.0826234009764744e-06 0.022960000000000001 2.191277414638715e-06 0.022970000000000001 -3.6248387461273029e-06 0.02298 -3.3867527985694192e-06 0.022990000000000003 -1.9476999219134709e-06 0.023000000000000003 -6.6357825402269729e-07 0.023010000000000003 -3.7938478629577946e-06 0.023020000000000002 7.0817697482712052e-06 0.023030000000000002 1.8641565381283557e-06 0.023040000000000001 1.4405538545681318e-06 0.023050000000000001 -2.1074192525592138e-07 0.023060000000000001 4.8129621762105702e-06 0.02307 -7.738460974509661e-07 0.023080000000000003 7.4006459609493357e-06 0.023090000000000003 1.4587606769888827e-05 0.023100000000000002 -1.9660916904063249e-06 0.023110000000000002 -4.0394706069142411e-06 0.023120000000000002 2.8267254697615656e-06 0.023130000000000001 -6.0970327053024439e-06 0.023140000000000001 1.030787437916699e-05 0.02315 -7.3098635064147984e-06 0.023160000000000004 -3.0813388343935795e-06 0.023170000000000003 5.7641020721812205e-06 0.023180000000000003 1.3042614871788318e-05 0.023190000000000002 1.290306145241746e-07 0.023200000000000002 2.7804820541658023e-06 0.023210000000000001 5.2835604292580012e-06 0.023220000000000001 2.4398910011679768e-06 0.023230000000000001 2.105647547717204e-06 0.02324 2.7953549695845713e-06 0.023250000000000003 -2.3308700131090207e-06 0.023260000000000003 -2.6066274236002268e-06 0.023270000000000002 -5.8715316991101782e-06 0.023280000000000002 -9.7380356694163204e-07 0.023290000000000002 -1.8600845940667261e-06 0.023300000000000001 2.4230229786191456e-06 0.023310000000000001 5.7996893516931581e-06 0.02332 -2.5677894706808022e-06 0.023330000000000004 2.3971882710552848e-08 0.023340000000000003 -1.3835148085921397e-06 0.023350000000000003 -5.5754588551607861e-06 0.023360000000000002 2.9325004252325275e-07 0.023370000000000002 3.9281910107107619e-07 0.023380000000000001 2.8930192592358836e-06 0.023390000000000001 8.7692428466722981e-06 0.023400000000000001 6.8268292396942819e-06 0.02341 5.7166791834134557e-06 0.023420000000000003 7.6484099447073858e-07 0.023430000000000003 5.1910176535962421e-06 0.023440000000000003 -2.5655103883958031e-06 0.023450000000000002 -3.1798926324263657e-06 0.023460000000000002 2.4038383804613306e-06 0.023470000000000001 5.1277519656871686e-06 0.023480000000000001 4.2773322388083218e-06 0.02349 5.6025439140922114e-06 0.023500000000000004 1.9483853594431585e-06 0.023510000000000003 -5.3890517452085221e-06 0.023520000000000003 5.2811731298836389e-06 0.023530000000000002 6.3747775214059783e-06 0.023540000000000002 7.7942300832660029e-06 0.023550000000000001 5.0215200245475762e-06 0.023560000000000001 -1.5134873340825462e-05 0.023570000000000001 -5.5490124260188962e-06 0.02358 -9.5209222570561112e-06 0.023590000000000003 4.045732534297154e-07 0.023600000000000003 2.4521642651467292e-07 0.023610000000000003 6.044955640987691e-06 0.023620000000000002 -1.4479067182895948e-06 0.023630000000000002 3.2795915493820153e-06 0.023640000000000001 8.9416298172346198e-06 0.023650000000000001 -6.7077326219887939e-06 0.02366 1.364142623049988e-06 0.023670000000000004 -3.6715052618686463e-07 0.023680000000000003 -2.3570022624847434e-06 0.023690000000000003 2.5896514609909253e-06 0.023700000000000002 -6.6307630658846644e-06 0.023710000000000002 -1.9469203850262607e-06 0.023720000000000001 8.8368988497581872e-06 0.023730000000000001 3.3225368909902566e-06 0.023740000000000001 -1.1473067921527272e-05 0.02375 5.0920076635733914e-06 0.023760000000000003 5.4453356464418557e-06 0.023770000000000003 3.2075188228783766e-06 0.023780000000000003 -2.019269370756638e-06 0.023790000000000002 -2.3990393867183764e-07 0.023800000000000002 9.3814756900891159e-06 0.023810000000000001 9.7073545061431405e-06 0.023820000000000001 3.1647187125819633e-07 0.02383 1.1024947697651768e-06 0.023840000000000004 -1.579279655071816e-06 0.023850000000000003 -9.5713705395018225e-06 0.023860000000000003 4.2048028378991221e-06 0.023870000000000002 -3.2072240254863597e-06 0.023880000000000002 -1.9831345512503742e-06 0.023890000000000002 4.0814348331851521e-06 0.023900000000000001 -9.5065483941189151e-07 0.023910000000000001 2.61067919036188e-06 0.02392 4.0736773295043656e-06 0.023930000000000003 6.0915124977840535e-06 0.023940000000000003 2.32284298473197e-06 0.023950000000000003 5.0204205397453978e-06 0.023960000000000002 3.4900641298734219e-06 0.023970000000000002 2.9477761715817647e-06 0.023980000000000001 5.7660306046444311e-06 0.023990000000000001 -6.6345525695774293e-06 0.024 2.6568390554604785e-06)
Bq q_drive 0 V=min(2,max(-2,(v(state)+-5.4999999999999995e-05+v(readnoise)+(5.5015087127685547e-05)+(0.00019997358322143555)*v(state))))
Rq q_drive q 10
Cq q 0 9.9999999999999995e-08
Rport_q q 0 50000
Cport_q q 0 2p
Bd0 d0_drive 0 V=min(2,max(-2,(v(q)+0.071428596973419189*((1+-0.0016)*v(q)*v(q)+-5.4999999999999995e-05)+-5.4999999999999995e-05+(5.8948993682861328e-05)+(0.00020009279251098633)*v(q)+(0)*v(q)+(0.00012874603271484375)*v(q)*v(q)+(0)*v(q)*v(q))))
Rd0 d0_drive d0 10
Cd0 d0 0 9.9999999999999995e-08
Rport_d0 d0 0 50000
Cport_d0 d0 0 2p
Bd1 d1_drive 0 V=min(2,max(-2,(v(d0)+0.33333331346511841*(v(q)-v(d0))+0.095238089561462402*((1+-0.0016)*v(d0)*v(q)+-5.4999999999999995e-05)+-5.4999999999999995e-05+(6.0319900512695312e-05)+(0.00013339519500732422)*v(d0)+(6.6816806793212891e-05)*v(q)+(0)*v(d0)*v(d0)+(0.00017172098159790039)*v(d0)*v(q))))
Rd1 d1_drive d1 10
Cd1 d1 0 9.9999999999999995e-08
Rport_d1 d1 0 50000
Cport_d1 d1 0 2p
Bd2 d2_drive 0 V=min(2,max(-2,(v(d1)+0.21428573131561279*((1+-0.0016)*v(d1)*v(d1)+-5.4999999999999995e-05)+-5.4999999999999995e-05+(6.6816806793212891e-05)+(0.00020009279251098633)*v(d1)+(0)*v(q)+(0.00038570165634155273)*v(d1)*v(d1)+(0)*v(d1)*v(q))))
Rd2 d2_drive d2 10
Cd2 d2 0 9.9999999999999995e-08
Rport_d2 d2 0 50000
Cport_d2 d2 0 2p
Bd3 d3_drive 0 V=min(2,max(-2,(v(d2)+0.1428571343421936*(v(q)-v(d2))+0.12244898080825806*((1+-0.0016)*v(d2)*v(q)+-5.4999999999999995e-05)+-5.4999999999999995e-05+(6.1750411987304688e-05)+(0.00017142295837402344)*v(d2)+(2.86102294921875e-05)*v(q)+(0)*v(d2)*v(d2)+(0.00022047758102416992)*v(d2)*v(q))))
Rd3 d3_drive d3 10
Cd3 d3 0 9.9999999999999995e-08
Rport_d3 d3 0 50000
Cport_d3 d3 0 2p
Bpeak stagepeak 0 V=max(max(max(max(abs(v(q_drive)),abs(v(d0_drive))),abs(v(d1_drive))),abs(v(d2_drive))),abs(v(d3_drive)))
Bres residual 0 V=1.5309010148048401*(1+v(d3))
Bden denominator 0 V=1+v(residual)+(v(residual)-1)*0.1428571343421936
Btarget target 0 V=(((v(q)+v(delta))*(1+(-0.0016000000000000001))+(-5.4999999999999995e-05)+v(targetnoise))-(-5.5015087127685547e-05))/(0.99839991331100464)
Bcandidate candidate_drive 0 V=min(2,max(-2,v(target)))
Rcandidate candidate_drive candidate 10
Ccandidate candidate 0 100n
Bcorr_first corr_first_drive 0 V=min(2,max(-2,((1+(-0.0016000000000000001))*((1+(0.1428571343421936)*(v(q)))+(0.5714285671710968)*v(delta))+(-5.4999999999999995e-05)+(5.5015087127685547e-05)+(0.0018000006675720215)*((1+(0.1428571343421936)*(v(q)))+(0.5714285671710968)*v(delta)))+v(cornoise0)))
Rcorr_first corr_first_drive corr_first 10
Ccorr_first corr_first 0 9.9999999999999995e-08
Rport_corr_first corr_first 0 50000
Cport_corr_first corr_first 0 2p
Bcorr_first_raw corr_first_raw 0 V=((1+(-0.0016000000000000001))*((1+(0.1428571343421936)*(v(q)))+(0.5714285671710968)*v(delta))+(-5.4999999999999995e-05)+(5.5015087127685547e-05)+(0.0018000006675720215)*((1+(0.1428571343421936)*(v(q)))+(0.5714285671710968)*v(delta)))+v(cornoise0)
Bdelta delta_drive 0 V=min(2,max(-2,((1+(-0.0016000000000000001))*(-((v(residual)-1))*v(corr_first))+(-5.4999999999999995e-05)+(5.5015087127685547e-05)+(0.0018000006675720215)*(-((v(residual)-1))*v(corr_first)))+v(cornoise1)))
Rdelta delta_drive delta 10
Cdelta delta 0 9.9999999999999995e-08
Rport_delta delta 0 50000
Cport_delta delta 0 2p
Bdelta_raw delta_raw 0 V=((1+(-0.0016000000000000001))*(-((v(residual)-1))*v(corr_first))+(-5.4999999999999995e-05)+(5.5015087127685547e-05)+(0.0018000006675720215)*(-((v(residual)-1))*v(corr_first)))+v(cornoise1)
Bcorpeak corpeak 0 V=max(abs(v(corr_first_raw)),abs(v(delta_raw)))
Binnerden innerden 0 V=1+(0.5714285671710968)*((v(residual)-1))
Vcornoise0 cornoise0 0 PWL(0 -6.1609818444931872e-06 1.0000000000000001e-05 7.5995448952869576e-06 2.0000000000000002e-05 2.9266156622109687e-06 3.0000000000000004e-05 3.1740755026516416e-06 4.0000000000000003e-05 -1.4562487689477537e-05 5.0000000000000002e-05 -3.5736311641329142e-06 6.0000000000000008e-05 3.2022230006545689e-06 7.0000000000000007e-05 6.2437466276609041e-06 8.0000000000000007e-05 -9.5347525056869324e-06 9.0000000000000006e-05 -9.4405985048994452e-06 0.0001 2.6258841140300289e-06 0.00011 9.3637366016598415e-08 0.00012000000000000002 -6.4131929109634472e-06 0.00013000000000000002 -2.4028436217460864e-06 0.00014000000000000001 -7.3350029996228619e-06 0.00015000000000000001 1.0924624664410598e-05 0.00016000000000000001 3.984968229799975e-06 0.00017000000000000001 -4.7866864728326278e-06 0.00018000000000000001 -4.6497788795079488e-06 0.00019000000000000001 -1.3184504582574572e-06 0.00020000000000000001 8.8759685724447136e-06 0.00021000000000000001 -7.8115453356538759e-06 0.00022000000000000001 -3.656226473759792e-06 0.00023000000000000001 -8.7756996263131174e-06 0.00024000000000000003 -5.1488732199375531e-06 0.00025000000000000001 7.0948346588978401e-06 0.00026000000000000003 -1.0011634043425982e-06 0.00027 -8.7092002336188015e-06 0.00028000000000000003 -1.327238412321954e-06 0.00029 -9.3258551491120529e-06 0.00030000000000000003 1.1104210149315085e-05 0.00031 1.1456646749137163e-06 0.00032000000000000003 1.4231276967745918e-06 0.00033000000000000005 2.1010456444677641e-06 0.00034000000000000002 5.2892799895957899e-06 0.00035000000000000005 -4.5415052209512768e-06 0.00036000000000000002 -2.1086865830317451e-06 0.00037000000000000005 -5.1531874539238887e-06 0.00038000000000000002 4.8942432499582341e-06 0.00039000000000000005 -4.397910771019852e-06 0.00040000000000000002 -8.3596210851456913e-07 0.00041000000000000005 5.9788475014767937e-06 0.00042000000000000002 -2.5808473852773586e-07 0.00043000000000000004 6.8265576344624819e-06 0.00044000000000000002 5.6035127854577272e-06 0.00045000000000000004 2.1547541933669765e-06 0.00046000000000000001 -8.7790271828202312e-07 0.00047000000000000004 5.8862288127491528e-06 0.00048000000000000007 -9.925514883364178e-07 0.00049000000000000009 -2.5343542487658811e-06 0.00050000000000000001 8.1609564589891004e-06 0.00051000000000000004 -5.0290087268297257e-06 0.00052000000000000006 6.3757880771570127e-06 0.00053000000000000009 3.4871071895464516e-06 0.00054000000000000001 -6.5130527974804465e-06 0.00055000000000000003 8.0681754249198485e-07 0.00056000000000000006 -4.5890451042021052e-06 0.00057000000000000009 2.9093620259411539e-07 0.00058 -7.3342519124126739e-06 0.00059000000000000003 -1.839553053885498e-06 0.00060000000000000006 -4.284675598149755e-06 0.00061000000000000008 4.0261450819541477e-06 0.00062 -1.1281733230493566e-06 0.00063000000000000003 1.7337854243867224e-07 0.00064000000000000005 8.5756208540857159e-07 0.00065000000000000008 -6.507454211997538e-06 0.0006600000000000001 1.2772934286289442e-05 0.00067000000000000002 7.6603423732783617e-06 0.00068000000000000005 3.4833330451064175e-06 0.00069000000000000008 -3.085938434458362e-06 0.0007000000000000001 -1.3343418798224928e-06 0.00071000000000000002 -8.700516679903353e-06 0.00072000000000000005 1.7471926334819262e-06 0.00073000000000000007 -5.2083267325788502e-06 0.0007400000000000001 4.2370403603103691e-06 0.00075000000000000002 8.4560314657526584e-06 0.00076000000000000004 4.6043807208849435e-06 0.00077000000000000007 7.0448172677784435e-06 0.00078000000000000009 5.5023311522085177e-06 0.00079000000000000001 6.2408753409215441e-07 0.00080000000000000004 5.3385290386888676e-06 0.00081000000000000006 -7.6646457634946327e-07 0.00082000000000000009 6.2214003790713355e-06 0.00083000000000000012 -5.8889714562532828e-06 0.00084000000000000003 1.8464117996533012e-06 0.00085000000000000006 1.3624503910688797e-06 0.00086000000000000009 -4.0930039872499827e-07 0.00087000000000000011 -5.7199451773762308e-06 0.00088000000000000003 -5.5901268200215438e-06 0.00089000000000000006 -2.3163781419438266e-06 0.00090000000000000008 -2.488704700365494e-06 0.00091000000000000011 -5.8588528534085374e-06 0.00092000000000000003 3.6716973685098157e-07 0.00093000000000000005 6.3598600949154556e-06 0.00094000000000000008 -1.3464281481589588e-06 0.00095000000000000011 -6.0053190053442301e-06 0.00096000000000000013 -1.6023209101497691e-06 0.00097000000000000005 -3.2903913411295499e-08 0.00098000000000000019 2.8777888116853419e-06 0.00098999999999999999 -3.094698698469747e-06 0.001 -5.0411453115640194e-07 0.00101 -1.8099788302357501e-06 0.0010200000000000001 -1.3772800414237512e-06 0.0010300000000000001 -3.3239164484642795e-06 0.0010400000000000001 -2.7485718596811372e-06 0.0010500000000000002 -4.0991645252666635e-07 0.0010600000000000002 3.4809387992514631e-06 0.00107 -6.3352026527268117e-06 0.00108 -7.591225103688823e-07 0.00109 6.3401673862281932e-06 0.0011000000000000001 -1.7644403451676182e-06 0.0011100000000000001 -3.1808759965819765e-06 0.0011200000000000001 1.5149301545718231e-06 0.0011300000000000001 1.364352485797221e-06 0.0011400000000000002 -1.7248373949706632e-06 0.0011500000000000002 4.7031589123778539e-06 0.00116 1.7461523214815768e-06 0.00117 -2.8422671181675963e-06 0.0011800000000000001 4.4077292160427949e-06 0.0011900000000000001 1.2552103370210778e-06 0.0012000000000000001 -1.6538180104549364e-06 0.0012100000000000001 2.1365426797797016e-06 0.0012200000000000002 6.9637005081846012e-06 0.0012300000000000002 2.6763344672307901e-06 0.00124 -6.6763161545846118e-06 0.00125 -9.5915454264094869e-06 0.0012600000000000001 -7.4995959355563792e-07 0.0012700000000000001 -1.0983201416064308e-05 0.0012800000000000001 2.130762262961388e-06 0.0012900000000000001 7.8895956757365249e-07 0.0013000000000000002 7.7890243113250507e-06 0.0013100000000000002 7.5298335042577122e-06 0.0013200000000000002 9.9699441806270333e-07 0.00133 -4.1746299217510703e-06 0.00134 8.6196569467646468e-07 0.0013500000000000001 -8.7887727060124221e-06 0.0013600000000000001 6.854590736039054e-06 0.0013700000000000001 -6.1933287730702306e-06 0.0013800000000000002 -7.401889977916813e-06 0.0013900000000000002 -6.1593601669239278e-06 0.0014000000000000002 3.2785715622300218e-06 0.00141 -3.9740113361193148e-06 0.00142 -3.2254326629019293e-06 0.0014300000000000001 3.377112181545091e-06 0.0014400000000000001 -2.8982097767966556e-06 0.0014500000000000001 6.543335120530113e-06 0.0014600000000000001 3.259742384121179e-06 0.0014700000000000002 7.3092575019827195e-06 0.0014800000000000002 -8.4913672660831574e-07 0.0014900000000000002 4.4651742732955698e-06 0.0015 6.7663895802898225e-06 0.0015100000000000001 3.7589224220136071e-06 0.0015200000000000001 -9.3222125894408723e-07 0.0015300000000000001 2.6142260680861623e-06 0.0015400000000000001 -4.5853930307611215e-06 0.0015500000000000002 -1.9383727463292483e-07 0.0015600000000000002 -2.2907251545335311e-06 0.0015700000000000002 4.9797674141381705e-06 0.00158 -6.2359647923088581e-06 0.0015900000000000001 -4.6785822295987068e-06 0.0016000000000000001 2.8812682703169116e-06 0.0016100000000000001 5.0525832685956403e-07 0.0016200000000000001 4.7180424198565106e-06 0.0016300000000000002 7.020258064417909e-06 0.0016400000000000002 6.3583701994858123e-06 0.0016500000000000002 -1.1922444166759449e-05 0.0016600000000000002 -6.8223564437984528e-07 0.00167 -5.3503582253560901e-06 0.0016800000000000001 7.6312416300654845e-06 0.0016900000000000001 -3.3980101403830345e-06 0.0017000000000000001 -6.6505893767119633e-06 0.0017100000000000001 -2.308045436378621e-06 0.0017200000000000002 -5.3112896937732039e-06 0.0017300000000000002 8.6144372616679266e-06 0.0017400000000000002 -1.0514732203421798e-05 0.00175 -7.7392539978831592e-07 0.0017600000000000001 8.5935021138404866e-06 0.0017700000000000001 4.5574884491306539e-06 0.0017800000000000001 2.267429304991179e-06 0.0017900000000000001 -5.8595669800561327e-06 0.0018000000000000002 3.6752036215268281e-06 0.0018100000000000002 1.8882711021766534e-06 0.0018200000000000002 -3.4564301240787369e-06 0.0018300000000000002 -4.9047955924465669e-06 0.0018400000000000001 7.5369573118601694e-06 0.0018500000000000001 9.3099698660988652e-06 0.0018600000000000001 6.0034812983196397e-06 0.0018700000000000001 -9.1786513751794069e-06 0.0018800000000000002 4.6434641321356561e-06 0.0018900000000000002 -1.5151881372204735e-06 0.0019000000000000002 3.7066930417521976e-07 0.0019100000000000002 2.9736518418868627e-06 0.0019200000000000003 -3.1589094200254121e-06 0.0019300000000000001 -3.8597091918284097e-06 0.0019400000000000001 2.01116662851947e-06 0.0019500000000000001 -3.7406096216528344e-06 0.0019600000000000004 3.1836207856752142e-06 0.00197 2.6937453113598038e-06 0.00198 1.6023193603939375e-06 0.00199 2.9447384764041569e-06 0.002 1.5288546887031886e-06 0.0020100000000000001 4.8194335942784778e-06 0.0020200000000000001 -2.4011720349694732e-06 0.0020300000000000001 -2.7786171570573245e-06 0.0020400000000000001 1.9654597637189324e-07 0.0020500000000000002 2.9957241344294926e-07 0.0020600000000000002 -4.9110452981926007e-06 0.0020700000000000002 2.8476318321171225e-06 0.0020800000000000003 -3.1146027749485006e-06 0.0020900000000000003 -1.343911936983111e-06 0.0021000000000000003 -3.7948957971701932e-06 0.0021100000000000003 5.0623549068489328e-07 0.0021200000000000004 -1.7704150001707301e-06 0.0021300000000000004 5.7787921168191641e-06 0.00214 -1.6330270659878497e-06 0.00215 6.9860319936303422e-07 0.00216 -7.1960327668340757e-06 0.0021700000000000001 -2.7950871450643592e-06 0.0021800000000000001 8.6788252512943827e-08 0.0021900000000000001 1.007713800767994e-06 0.0022000000000000001 3.2244690715399313e-06 0.0022100000000000002 4.4590431308709866e-06 0.0022200000000000002 4.3676365949443942e-06 0.0022300000000000002 -2.6921910819964262e-06 0.0022400000000000002 -1.3569160723060253e-06 0.0022500000000000003 3.4181933860306902e-06 0.0022600000000000003 1.2945271914840297e-06 0.0022700000000000003 1.0377494565881569e-05 0.0022800000000000003 1.6058528447394437e-06 0.0022900000000000004 -2.6028266646485863e-06 0.0023000000000000004 -2.5258690202803278e-06 0.00231 4.7780990695428151e-06 0.00232 -1.2163295097639256e-06 0.00233 -5.1872768412439341e-07 0.0023400000000000001 7.8777231902120789e-06 0.0023500000000000001 -9.179402746584524e-06 0.0023600000000000001 6.2455630360335426e-06 0.0023700000000000001 1.5976388044707605e-06 0.0023800000000000002 5.7623972974662238e-06 0.0023900000000000002 6.3927282289974653e-06 0.0024000000000000002 1.2968944760178998e-06 0.0024100000000000002 3.8258756604672398e-06 0.0024200000000000003 5.4564675451992853e-06 0.0024300000000000003 1.4026967651985878e-07 0.0024400000000000003 -6.1073922369208472e-06 0.0024500000000000004 -6.862678896769399e-06 0.0024600000000000004 3.9664682105409641e-06 0.0024700000000000004 -5.5771687344912825e-06 0.00248 1.8361554408584421e-06 0.00249 1.414551751014715e-06 0.0025000000000000001 1.7722617525042952e-06 0.0025100000000000001 -9.1805410855356233e-06 0.0025200000000000001 2.8683093863243709e-06 0.0025300000000000001 5.8516470520721477e-06 0.0025400000000000002 -3.6246604610687751e-06 0.0025500000000000002 -3.0813706942227523e-06 0.0025600000000000002 -8.5915790986473081e-07 0.0025700000000000002 7.0834481239611952e-06 0.0025800000000000003 -9.9393912409812636e-06 0.0025900000000000003 5.999924157248197e-06 0.0026000000000000003 3.5995718789057731e-06 0.0026100000000000003 6.7038674532995387e-06 0.0026200000000000004 4.449443762750711e-07 0.0026300000000000004 -2.9723471529896731e-06 0.0026400000000000004 2.8541820170517355e-06 0.00265 -2.5952265487310901e-06 0.00266 5.9730531236769969e-06 0.0026700000000000001 2.5280026126351243e-06 0.0026800000000000001 1.417508716360532e-06 0.0026900000000000001 -6.523055280623317e-06 0.0027000000000000001 -5.8353458623876781e-06 0.0027100000000000002 3.3437083793971872e-06 0.0027200000000000002 2.851066694075744e-06 0.0027300000000000002 -1.4298937648216193e-06 0.0027400000000000002 -1.4086146035046259e-06 0.0027500000000000003 6.5294763605388736e-06 0.0027600000000000003 5.4558460018189011e-06 0.0027700000000000003 -1.3221368157523771e-06 0.0027800000000000004 -4.1583820363039471e-06 0.0027900000000000004 9.2800234072253963e-06 0.0028000000000000004 5.8686345824423745e-07 0.0028100000000000004 3.3928657232813187e-06 0.00282 4.6988047865030952e-06 0.0028300000000000001 4.8363800751011279e-06 0.0028400000000000001 5.0636135174696924e-06 0.0028500000000000001 -3.1367142251178958e-06 0.0028600000000000001 2.5543528771399122e-06 0.0028700000000000002 -1.2577335025316451e-06 0.0028800000000000002 -2.7185280033039717e-06 0.0028900000000000002 -9.1398804938156773e-06 0.0029000000000000002 -6.3494502101015241e-06 0.0029100000000000003 3.1817031579538886e-06 0.0029200000000000003 -7.2211618791613182e-06 0.0029300000000000003 -1.0586767176992462e-05 0.0029400000000000003 -7.3479902285600221e-06 0.0029500000000000004 5.4586485935965637e-06 0.0029600000000000004 -1.4163155285602292e-05 0.0029700000000000004 -1.9361339668938296e-06 0.0029800000000000004 -2.6831000291922805e-06 0.00299 -5.9235840316188191e-06 0.0030000000000000001 -1.0833278268898653e-06 0.0030100000000000001 -1.0545811667998031e-06 0.0030200000000000001 -8.9986644775304185e-06 0.0030300000000000001 -2.1392673525169182e-07 0.0030400000000000002 -2.4025958305023668e-06 0.0030500000000000002 1.6054456586818354e-06 0.0030600000000000002 -3.2686371872152538e-06 0.0030700000000000002 9.0747664761112727e-07 0.0030800000000000003 -1.12463102028945e-05 0.0030900000000000003 -6.7449093034827537e-07 0.0031000000000000003 8.0243808294011696e-06 0.0031100000000000004 -1.2924472298604635e-06 0.0031200000000000004 -2.8826857866601659e-06 0.0031300000000000004 9.6949868844691688e-06 0.0031400000000000004 8.5401142762970802e-06 0.0031500000000000005 3.5797649192154533e-06 0.00316 -1.4878785220594594e-07 0.0031700000000000001 -4.0376872246707168e-06 0.0031800000000000001 -1.8367068729294584e-06 0.0031900000000000001 -4.516646896700342e-06 0.0032000000000000002 -6.9020916844440556e-06 0.0032100000000000002 4.3368528118545563e-06 0.0032200000000000002 -5.6560393931389335e-06 0.0032300000000000002 -7.8994217269061469e-06 0.0032400000000000003 1.9571025891120225e-06 0.0032500000000000003 -2.3409158159974683e-06 0.0032600000000000003 6.6078166533645213e-06 0.0032700000000000003 3.6900604821420831e-06 0.0032800000000000004 -3.8744814001031672e-07 0.0032900000000000004 -9.5800086399627087e-07 0.0033000000000000004 6.2772752249982486e-06 0.0033100000000000004 1.4957045086154073e-06 0.0033200000000000005 -4.6643766151286873e-06 0.0033300000000000001 9.0831130452330502e-06 0.0033400000000000001 -3.0043857023257206e-06 0.0033500000000000001 -2.9313347491753442e-06 0.0033600000000000001 -2.1798040946961828e-06 0.0033700000000000002 -4.1260152291078074e-07 0.0033800000000000002 7.0140315180988414e-06 0.0033900000000000002 4.9740745767216768e-06 0.0034000000000000002 -5.5134965646617988e-07 0.0034100000000000003 3.6118129946978292e-06 0.0034200000000000003 -1.578760718304142e-06 0.0034300000000000003 -4.983894377381862e-06 0.0034400000000000003 -2.9805775774620655e-06 0.0034500000000000004 2.3695282741841265e-06 0.0034600000000000004 2.7349642880538337e-06 0.0034700000000000004 -1.1018664779007325e-06 0.0034800000000000005 -5.1425222278286978e-06 0.0034900000000000005 1.8508637672497192e-06 0.0035000000000000001 1.9002853865441858e-06 0.0035100000000000001 7.0029147705354768e-06 0.0035200000000000001 -2.214254906072948e-06 0.0035300000000000002 -8.6516183215619328e-06 0.0035400000000000002 -3.0577899653010606e-06 0.0035500000000000002 1.1448752514645344e-06 0.0035600000000000002 5.2578470127096812e-06 0.0035700000000000003 -5.5060026136891108e-06 0.0035800000000000003 3.2878308445085228e-06 0.0035900000000000003 1.5730504111816959e-08 0.0036000000000000003 -5.0578257762377202e-06 0.0036100000000000004 4.8913857625055994e-07 0.0036200000000000004 7.2247199363262256e-07 0.0036300000000000004 -4.8134406266940234e-06 0.0036400000000000004 -2.880317697078004e-06 0.0036500000000000005 9.5815688753152154e-06 0.0036600000000000005 -1.7300254494698598e-07 0.0036700000000000001 -1.2051780682760938e-06 0.0036800000000000001 -4.9024682666608466e-06 0.0036900000000000001 -2.4964155986938064e-06 0.0037000000000000002 -4.7588925335531491e-06 0.0037100000000000002 -1.4328444751054811e-05 0.0037200000000000002 1.6174638645743698e-06 0.0037300000000000002 5.3870896626169335e-06 0.0037400000000000003 -2.8881279220647588e-06 0.0037500000000000003 1.8782733644065428e-06 0.0037600000000000003 5.7726591553399804e-06 0.0037700000000000003 -2.6777840035638907e-06 0.0037800000000000004 -1.4378173397874259e-06 0.0037900000000000004 1.0491687465396142e-06 0.0038000000000000004 -8.5915236589996453e-07 0.0038100000000000005 -6.9959330870503414e-06 0.0038200000000000005 -1.019424382128358e-05 0.0038300000000000005 2.1872674264375691e-07 0.0038400000000000005 -7.1399555324040215e-06 0.0038500000000000001 5.0706854188951883e-06 0.0038600000000000001 8.8587142688156454e-06 0.0038700000000000002 4.4384149096270114e-06 0.0038800000000000002 -9.1835386889632162e-06 0.0038900000000000002 -8.0166152501223642e-07 0.0039000000000000003 -1.4829764143780296e-06 0.0039100000000000003 7.0929856819056838e-06 0.0039200000000000007 -7.6465729501064561e-06 0.0039300000000000003 -2.4388359991226122e-07 0.0039399999999999999 -9.3193225584710627e-06 0.0039500000000000004 2.5040136925261223e-07 0.00396 7.429564697773298e-06 0.0039700000000000004 5.1760626746241475e-06 0.00398 -8.4375796807751413e-06 0.0039900000000000005 -8.7595516018196831e-06 0.0040000000000000001 6.2896190772493279e-06 0.0040100000000000005 -5.6548970912349741e-06 0.0040200000000000001 -3.5261537407879021e-06 0.0040300000000000006 3.3779934804900955e-06 0.0040400000000000002 1.6925178581229833e-05 0.0040500000000000006 -3.9325181393407816e-06 0.0040600000000000002 5.1215189126145529e-06 0.0040700000000000007 -1.73273819553265e-06 0.0040800000000000003 2.4086992699064872e-06 0.0040900000000000008 -1.924931864802861e-06 0.0041000000000000003 -2.1240762351459397e-09 0.0041099999999999999 1.9945467574099231e-06 0.0041200000000000004 6.857852154089433e-06 0.00413 1.4259583151750708e-06 0.0041400000000000005 -2.5447556836010025e-06 0.00415 3.5254311516001451e-06 0.0041600000000000005 2.8717549979261355e-06 0.0041700000000000001 -5.21645328439338e-07 0.0041800000000000006 -2.6029190363769772e-06 0.0041900000000000001 -4.6491655975160395e-06 0.0042000000000000006 -7.2562753250798452e-07 0.0042100000000000002 -8.5635944250588892e-06 0.0042200000000000007 5.612503009635607e-07 0.0042300000000000003 -3.8265916422047997e-06 0.0042400000000000007 -4.737983713393351e-06 0.0042500000000000003 4.007210958168981e-06 0.0042600000000000008 9.014272710903617e-06 0.0042700000000000004 -2.6109437560966949e-06 0.00428 -5.9593445139139281e-06 0.0042900000000000004 4.2163412255668053e-06 0.0043 8.8647761453069194e-06 0.0043100000000000005 3.3103074846780138e-06 0.0043200000000000001 -9.1894739178831669e-07 0.0043300000000000005 5.2247570762449993e-06 0.0043400000000000001 3.7996545245954926e-06 0.0043500000000000006 4.7248351499807849e-06 0.0043600000000000002 -3.5400694690449032e-06 0.0043700000000000006 1.0008696433690543e-06 0.0043800000000000002 6.1316404593765375e-07 0.0043900000000000007 -7.6298285365877325e-08 0.0044000000000000003 -3.8656765394752516e-07 0.0044100000000000007 -5.6574830300649387e-06 0.0044200000000000003 1.5209936940709747e-06 0.0044300000000000008 -1.5567356513549317e-07 0.0044400000000000004 2.2228932670293706e-06 0.00445 2.2693340752414947e-06 0.0044600000000000004 -2.9909386332679399e-07 0.00447 2.5495182043979129e-07 0.0044800000000000005 -4.2258101799172596e-06 0.0044900000000000001 8.7075668677750797e-06 0.0045000000000000005 7.6862464983361849e-06 0.0045100000000000001 -4.2275363015299572e-06 0.0045200000000000006 6.5960785276732705e-07 0.0045300000000000002 5.2725929079612059e-07 0.0045400000000000006 5.8789315531083009e-06 0.0045500000000000002 1.2336792922722537e-06 0.0045600000000000007 -6.2778628746158195e-06 0.0045700000000000003 -2.3334443228262205e-06 0.0045800000000000007 3.3907669611836843e-06 0.0045900000000000003 4.8866929943701305e-06 0.0046000000000000008 -7.6457511453195456e-06 0.0046100000000000004 -4.0631523746917969e-06 0.00462 -1.7142861427586412e-06 0.0046300000000000004 4.6078711211398944e-06 0.00464 1.2947599077095441e-05 0.0046500000000000005 -2.4608615383520202e-06 0.0046600000000000001 2.6590484299071868e-06 0.0046700000000000005 -2.6211633121165643e-06 0.0046800000000000001 1.204007289046309e-05 0.0046900000000000006 -3.2186629443739752e-06 0.0047000000000000002 3.919055492176981e-06 0.0047100000000000006 -3.5448015761440008e-06 0.0047200000000000002 -2.502910237736723e-06 0.0047300000000000007 -2.4412636556875436e-06 0.0047400000000000003 9.6848971170005597e-07 0.0047500000000000007 6.8710492953911655e-06 0.0047600000000000003 3.0908296053957531e-06 0.0047700000000000008 -1.0098767549772357e-05 0.0047800000000000004 7.1735952917834743e-06 0.00479 -1.9540521412093336e-06 0.0048000000000000004 4.1471060442209231e-06 0.00481 -3.5354706558075047e-06 0.0048200000000000005 2.9215873781863196e-06 0.0048300000000000001 8.192511892025042e-06 0.0048400000000000006 4.3109245629019245e-06 0.0048500000000000001 6.5077522490516043e-06 0.0048600000000000006 2.8561925484312447e-06 0.0048700000000000002 1.1263664721852911e-06 0.0048800000000000007 1.6711134112414167e-06 0.0048900000000000002 3.2887542641901215e-06 0.0049000000000000007 -1.3496086573282455e-06 0.0049100000000000003 3.5157431766221016e-06 0.0049200000000000008 -3.988681810008635e-06 0.0049300000000000004 -9.890069488370714e-07 0.0049400000000000008 -4.3695302144323315e-06 0.0049500000000000004 -3.0959476053783015e-06 0.00496 -9.8194177661060212e-07 0.0049700000000000005 -2.7263659725259567e-06 0.0049800000000000001 -6.4126158805386581e-06 0.0049900000000000005 -5.7553466604381338e-06 0.0050000000000000001 -6.7824863238558596e-07 0.0050100000000000006 -6.8340149718360225e-08 0.0050200000000000002 -9.0293174945244161e-06 0.0050300000000000006 3.285921337860152e-07 0.0050400000000000002 -3.6065087114376882e-06 0.0050500000000000007 4.3091456076670011e-06 0.0050600000000000003 1.740758262586762e-05 0.0050700000000000007 -6.2900013486130004e-07 0.0050800000000000003 1.9041654507581651e-07 0.0050900000000000008 -1.05974021192855e-06 0.0051000000000000004 2.7922886385587521e-06 0.0051100000000000008 9.3166717099542485e-06 0.0051200000000000004 -6.1757730815541716e-06 0.00513 -8.5476637798013892e-06 0.0051400000000000005 4.4370840851879829e-06 0.0051500000000000001 3.3297926452747226e-06 0.0051600000000000005 5.3815812206615689e-07 0.0051700000000000001 5.4590237988282643e-06 0.0051800000000000006 1.7592997500801903e-06 0.0051900000000000002 3.3330270918947626e-06 0.0052000000000000006 6.3998648489626588e-06 0.0052100000000000002 2.3625001334836819e-06 0.0052200000000000007 -3.4350275320876786e-06 0.0052300000000000003 -4.0532777171885582e-06 0.0052400000000000007 9.8264478190702241e-07 0.0052500000000000003 -6.0038349091614236e-06 0.0052600000000000008 -2.5844536527451264e-06 0.0052700000000000004 1.0156024127419345e-07 0.0052800000000000008 -4.1328114961541226e-06 0.0052900000000000004 4.1163940331263239e-06 0.0053 -1.0513097547201152e-05 0.0053100000000000005 6.6504550980044254e-06 0.0053200000000000001 -7.6556859376779134e-07 0.0053300000000000005 3.1433487852143945e-06 0.0053400000000000001 3.3669815934850227e-06 0.0053500000000000006 -3.7942952350046854e-06 0.0053600000000000002 6.7529325424174829e-06 0.0053700000000000006 -1.70851824685225e-06 0.0053800000000000002 -5.0768044512816219e-06 0.0053900000000000007 -3.2118127761367679e-06 0.0054000000000000003 8.8925383818309997e-06 0.0054100000000000007 -3.1820747012873526e-06 0.0054200000000000003 -1.5288620887706661e-06 0.0054300000000000008 2.1153725552490143e-06 0.0054400000000000004 -1.8262417160412961e-06 0.0054500000000000009 3.0430223655517162e-06 0.0054600000000000004 -3.7159149210306161e-06 0.00547 -3.25243145319744e-06 0.0054800000000000005 8.5880709965301014e-06 0.0054900000000000001 -2.0462998859768637e-06 0.0055000000000000005 4.5161908235323978e-06 0.0055100000000000001 -2.6570525051717562e-06 0.0055200000000000006 -2.1654831414627629e-06 0.0055300000000000002 3.862810798470266e-06 0.0055400000000000007 5.3497626488736351e-07 0.0055500000000000002 5.305143782022828e-07 0.0055600000000000007 -1.4241675169343006e-06 0.0055700000000000003 1.4487317227894388e-06 0.0055800000000000008 -2.0323662496056142e-06 0.0055900000000000004 3.9352579214456024e-06 0.0056000000000000008 -1.3824886061377207e-05 0.0056100000000000004 -2.6774606083168344e-06 0.0056200000000000009 -6.0947052453146191e-06 0.0056300000000000005 5.65255368890895e-08 0.00564 1.6462756905210669e-06 0.0056500000000000005 -6.9501536364595314e-06 0.0056600000000000001 -2.2534340466859649e-06 0.0056700000000000006 9.1291921079886425e-06 0.0056800000000000002 -1.7513637934878871e-06 0.0056900000000000006 -4.1398380509500909e-06 0.0057000000000000002 7.0932347821661657e-07 0.0057100000000000007 9.223959549082569e-07 0.0057200000000000003 -3.1784962444853101e-06 0.0057300000000000007 5.3319522406197269e-06 0.0057400000000000003 1.6196119172479668e-06 0.0057500000000000008 -1.9244090778883537e-06 0.0057600000000000004 -8.3564007898224194e-06 0.0057700000000000008 3.0728569178578993e-06 0.0057800000000000004 2.2495792040780359e-06 0.0057900000000000009 1.182840151361722e-06 0.0058000000000000005 1.4706280372691454e-08 0.0058100000000000001 -9.84128348147782e-07 0.0058200000000000005 1.0669608711618692e-06 0.0058300000000000001 1.4505218929137071e-06 0.0058400000000000006 -7.3355685414150866e-06 0.0058500000000000002 -1.6431520826730757e-06 0.0058600000000000006 1.6419221018891196e-06 0.0058700000000000002 -5.8131326882499826e-06 0.0058800000000000007 1.4409024142371759e-06 0.0058900000000000003 1.0023714105108034e-06 0.0059000000000000007 -5.491296205545883e-07 0.0059100000000000003 8.3231797830460212e-06 0.0059200000000000008 2.5171991003749098e-06 0.0059300000000000004 -2.6179544264599578e-06 0.0059400000000000008 -3.8921779105318125e-06 0.0059500000000000004 6.7474469299756518e-06 0.0059600000000000009 7.66802992952082e-06 0.0059700000000000005 -1.9182396224850243e-06 0.0059800000000000001 3.8890946159539558e-06 0.0059900000000000005 -1.4842739812985273e-06 0.0060000000000000001 2.6907368495472338e-06 0.0060100000000000006 -1.843153164369971e-06 0.0060200000000000002 3.7669966836976795e-06 0.0060300000000000006 -1.111222855432116e-06 0.0060400000000000002 3.4119050585344226e-06 0.0060500000000000007 -6.1794724986051634e-06 0.0060600000000000003 1.1726659056078021e-06 0.0060700000000000007 -1.5023100341561825e-05 0.0060800000000000003 6.2499019935818727e-06 0.0060900000000000008 -6.2275964575570517e-06 0.0061000000000000004 -1.127950919539132e-06 0.0061100000000000008 4.7033260987488923e-06 0.0061200000000000004 4.6562921051251748e-06 0.0061300000000000009 8.186209121440043e-06 0.0061400000000000005 4.9320570053055345e-06 0.0061500000000000001 -7.9716037891574576e-07 0.0061600000000000005 4.0388558659367362e-06 0.0061700000000000001 7.4912155453344149e-06 0.0061800000000000006 -1.3563066681548801e-06 0.0061900000000000002 9.9190418737716936e-06 0.0062000000000000006 1.8094421736360637e-06 0.0062100000000000002 1.693428538122479e-05 0.0062200000000000007 -4.1030092525126434e-06 0.0062300000000000003 -5.9471171192656898e-06 0.0062400000000000008 7.0010361990259346e-06 0.0062500000000000003 3.510057687131133e-06 0.0062600000000000008 -3.5284027306399367e-06 0.0062700000000000004 -1.5563960742308493e-06 0.0062800000000000009 2.1938020948497594e-06 0.0062900000000000005 7.4583244177929501e-06 0.0063000000000000009 -6.5333583250768093e-06 0.0063100000000000005 -9.5550334296831372e-06 0.0063200000000000001 3.8365814931679306e-06 0.0063300000000000006 4.5678025398371842e-06 0.0063400000000000001 -1.2308037386908265e-06 0.0063500000000000006 2.8146600122374713e-06 0.0063600000000000002 -1.3115441338961244e-06 0.0063700000000000007 1.4770141470016517e-06 0.0063800000000000003 3.3552418918707495e-06 0.0063900000000000007 -8.0134253909324327e-06 0.0064000000000000003 -4.0444018057890792e-06 0.0064100000000000008 5.1006258704961624e-07 0.0064200000000000004 1.3554448698590489e-05 0.0064300000000000008 -1.9986889848933757e-06 0.0064400000000000004 5.6798888183639746e-06 0.0064500000000000009 -3.4057512092306831e-06 0.0064600000000000005 -8.7919970756183032e-08 0.0064700000000000009 -6.3556638506874925e-06 0.0064800000000000005 1.8891516983721706e-06 0.0064900000000000001 9.4357742455775325e-06 0.0065000000000000006 1.9664337319827022e-06 0.0065100000000000002 -7.3961982871699434e-06 0.0065200000000000006 -8.9783390127908269e-07 0.0065300000000000002 2.7607773366505093e-06 0.0065400000000000007 9.2690651931500021e-06 0.0065500000000000003 -5.5924692478834886e-06 0.0065600000000000007 3.9662278813345823e-06 0.0065700000000000003 -1.256868154114614e-06 0.0065800000000000008 -4.2395350631232387e-06 0.0065900000000000004 4.9500218300878109e-06 0.0066000000000000008 1.2379251143926596e-06 0.0066100000000000004 7.5075999702414904e-06 0.0066200000000000009 -5.2722433295493848e-06 0.0066300000000000005 -1.1065277569072966e-05 0.0066400000000000009 6.0189794450316911e-06 0.0066500000000000005 -4.519326570926143e-06 0.0066600000000000001 2.6302623669350817e-06 0.0066700000000000006 1.5687447617467971e-06 0.0066800000000000002 7.4921347098672061e-06 0.0066900000000000006 1.082052552648905e-07 0.0067000000000000002 -5.5616197023070104e-07 0.0067100000000000007 1.1935903266175397e-06 0.0067200000000000003 1.6315833448595647e-06 0.0067300000000000007 -6.5925436126123441e-08 0.0067400000000000003 1.2019283608971841e-06 0.0067500000000000008 -2.085514120150174e-06 0.0067600000000000004 -6.3066676714804712e-06 0.0067700000000000008 1.2629727179045296e-06 0.0067800000000000004 -2.73859595426899e-06 0.0067900000000000009 2.4383082975176984e-06 0.0068000000000000005 4.4479606493072522e-06 0.0068100000000000009 1.3898696284898696e-06 0.0068200000000000005 8.5109464448087805e-06 0.0068300000000000001 1.1139914431885301e-06 0.0068400000000000006 -1.0449892254449254e-06 0.0068500000000000002 4.3396194464595967e-07 0.0068600000000000006 -5.0313427827478513e-06 0.0068700000000000002 -1.2824232721812374e-06 0.0068800000000000007 5.8964691101514912e-06 0.0068900000000000003 -6.6731336265183235e-06 0.0069000000000000008 -2.7796199047414247e-06 0.0069100000000000003 -5.9343880596838346e-06 0.0069200000000000008 -9.118059636230295e-07 0.0069300000000000004 -3.3832222519323512e-06 0.0069400000000000009 6.6423412653601923e-06 0.0069500000000000004 3.780509466843992e-06 0.0069600000000000009 -1.2482812982118231e-06 0.0069700000000000005 1.2090194500260139e-06 0.006980000000000001 -2.6226005856785509e-06 0.0069900000000000006 1.2275990579895003e-06 0.0070000000000000001 -4.1776356430254841e-06 0.0070100000000000006 -5.850647930231802e-06 0.0070200000000000002 5.6649501612089807e-06 0.0070300000000000007 -1.5043851333446527e-06 0.0070400000000000003 -1.005416836574273e-05 0.0070500000000000007 -2.7116920493358762e-06 0.0070600000000000003 -4.7631984140591381e-06 0.0070700000000000008 2.6008289494496166e-06 0.0070800000000000004 -4.776931849516545e-06 0.0070900000000000008 1.6944498941101018e-06 0.0071000000000000004 -2.3429371688950616e-06 0.0071100000000000009 3.3995728324727678e-06 0.0071200000000000005 -2.6870239057869733e-06 0.0071300000000000009 -2.7430209340346408e-06 0.0071400000000000005 9.9159689498359643e-06 0.007150000000000001 -2.8359192126201264e-06 0.0071600000000000006 1.1992227504611266e-05 0.0071700000000000002 -5.5847863082711439e-06 0.0071800000000000006 -9.1065826138037171e-06 0.0071900000000000002 1.1494350549243347e-06 0.0072000000000000007 -5.0232833378324198e-06 0.0072100000000000003 -8.3972805027206462e-06 0.0072200000000000007 -1.3979302657217375e-06 0.0072300000000000003 3.6740863348441948e-06 0.0072400000000000008 3.174244705500219e-06 0.0072500000000000004 -4.3398962276670678e-06 0.0072600000000000008 -4.4437283211946796e-06 0.0072700000000000004 -2.5575874105553438e-06 0.0072800000000000009 -3.995116326735357e-06 0.0072900000000000005 -4.9415544817623947e-06 0.0073000000000000009 -4.6479607081717423e-06 0.0073100000000000005 4.3255530287389766e-07 0.007320000000000001 -1.7883529175559917e-06 0.0073300000000000006 -1.0049740220189705e-06 0.0073400000000000002 -2.2001255654677818e-06 0.0073500000000000006 3.9049432676251061e-06 0.0073600000000000002 1.3728686905688319e-06 0.0073700000000000007 -3.3149294204157405e-06 0.0073800000000000003 5.3466940855103463e-06 0.0073900000000000007 -1.1099121066764734e-05 0.0074000000000000003 8.9766980357993371e-06 0.0074100000000000008 1.0480986861763257e-06 0.0074200000000000004 -2.5108126207166485e-06 0.0074300000000000008 -9.6194618585945692e-06 0.0074400000000000004 4.4031159132316346e-06 0.0074500000000000009 -5.6072706594767244e-07 0.0074600000000000005 1.6304705731286901e-06 0.0074700000000000009 7.4732902159123922e-07 0.0074800000000000005 -1.6433474077529773e-06 0.007490000000000001 8.9818762517962091e-06 0.0075000000000000006 -1.5892495603123935e-06 0.0075100000000000002 -1.0125219591517273e-06 0.0075200000000000006 -7.8850339767915725e-07 0.0075300000000000002 -3.9436476997372534e-06 0.0075400000000000007 -7.5625440549688819e-08 0.0075500000000000003 -1.8543647054016916e-06 0.0075600000000000007 3.4312889322140496e-06 0.0075700000000000003 -4.7009875417844423e-06 0.0075800000000000008 7.1434753555861647e-08 0.0075900000000000004 2.3030320381030083e-06 0.0076000000000000009 -1.9556638514351429e-06 0.0076100000000000004 -2.613611920826621e-06 0.0076200000000000009 1.0891053641580945e-05 0.0076300000000000005 -7.7614529202359087e-07 0.007640000000000001 -2.5614552329198627e-06 0.0076500000000000005 -2.3295245431136113e-06 0.007660000000000001 -2.8972626838128023e-06 0.0076700000000000006 -2.498005212636823e-06 0.0076800000000000011 -7.2880818232439018e-06 0.0076900000000000007 -3.8797509073800023e-06 0.0077000000000000002 -7.26271022843372e-06 0.0077100000000000007 2.834077018358133e-07 0.0077200000000000003 -4.5557513987534008e-06 0.0077300000000000008 -1.1840418678276613e-06 0.0077400000000000004 5.4614854820010865e-06 0.0077500000000000008 2.1152014446104264e-06 0.0077600000000000004 -7.2709762812093918e-06 0.0077700000000000009 2.3218160096656721e-06 0.0077800000000000005 6.2477060284634428e-06 0.0077900000000000009 1.695628610897674e-06 0.0078000000000000005 -8.9941158162656852e-06 0.007810000000000001 3.8396486120397126e-07 0.0078200000000000006 -3.4811135741488211e-06 0.0078300000000000002 4.0278900914969328e-06 0.0078400000000000015 4.7368737882376635e-07 0.0078500000000000011 9.8151816704257156e-06 0.0078600000000000007 2.3580035271653594e-06 0.0078700000000000003 1.3841811415435693e-06 0.0078799999999999999 5.4047578412295554e-06 0.0078900000000000012 -1.0614819114073407e-05 0.0079000000000000008 -6.3230277490444599e-06 0.0079100000000000004 -9.517391607645702e-06 0.00792 -9.5377529175268195e-06 0.0079300000000000013 -6.6350064929277876e-06 0.0079400000000000009 -6.4291995857599799e-06 0.0079500000000000005 4.1085744113094266e-06 0.0079600000000000001 1.0533074156616027e-06 0.0079700000000000014 4.2070584580630233e-06 0.007980000000000001 -4.3026857512646072e-06 0.0079900000000000006 6.8674259827190837e-06 0.0080000000000000002 -3.9649836555457823e-07 0.0080100000000000015 -7.5151694429004396e-06 0.0080200000000000011 -5.9220942128439034e-06 0.0080300000000000007 2.6884232603084093e-07 0.0080400000000000003 -5.2661687434081558e-06 0.0080499999999999999 5.51007227527275e-06 0.0080600000000000012 -4.1802996185634816e-06 0.0080700000000000008 5.4019898259140459e-06 0.0080800000000000004 -2.6967045948382737e-06 0.00809 2.2279561194074777e-06 0.0081000000000000013 -1.0371040417633367e-06 0.0081100000000000009 -6.1218509712918267e-07 0.0081200000000000005 1.9354610393420935e-07 0.0081300000000000001 -1.4863560932260796e-06 0.0081400000000000014 1.0706389041974384e-05 0.008150000000000001 -4.078393386121042e-06 0.0081600000000000006 4.591542832854671e-06 0.0081700000000000002 5.3021164909631551e-06 0.0081800000000000015 2.0224747773021409e-06 0.0081900000000000011 -1.5937322141533471e-06 0.0082000000000000007 -6.6103998627000414e-06 0.0082100000000000003 -6.6301612918892964e-06 0.0082199999999999999 -2.296633799259348e-06 0.0082300000000000012 8.7021592508075751e-07 0.0082400000000000008 4.8157538014011414e-06 0.0082500000000000004 1.1410686487559936e-05 0.00826 -2.9783318501506546e-06 0.0082700000000000013 1.1371980345374894e-06 0.0082800000000000009 3.7819043693570068e-06 0.0082900000000000005 -1.1424177924265086e-06 0.0083000000000000001 -1.2210373015545679e-06 0.0083100000000000014 8.248011349842956e-07 0.008320000000000001 5.4505448489396804e-06 0.0083300000000000006 5.3408220374016469e-06 0.0083400000000000002 -2.2738847947180877e-07 0.0083500000000000015 6.3567529319166153e-06 0.0083600000000000011 2.3115640059854485e-06 0.0083700000000000007 -6.5690507027192487e-07 0.0083800000000000003 -5.6105114031970866e-06 0.0083899999999999999 -6.321949841520242e-06 0.0084000000000000012 3.4126088338669784e-06 0.0084100000000000008 1.5240074119962728e-06 0.0084200000000000004 1.9642166113411628e-06 0.00843 -2.2078373672159663e-06 0.0084400000000000013 1.4794649109520631e-06 0.0084500000000000009 -7.6880419871187151e-07 0.0084600000000000005 5.7488802349853435e-06 0.0084700000000000001 6.4649586511279113e-06 0.0084800000000000014 -8.9668323679619709e-07 0.008490000000000001 3.6132048661612972e-06 0.0085000000000000006 -1.0633954559139678e-06 0.0085100000000000002 -4.4151836115248594e-06 0.0085200000000000015 -3.3474665603556039e-06 0.0085300000000000011 -6.5587414198731785e-07 0.0085400000000000007 2.0069838260012621e-06 0.0085500000000000003 4.6766938790106082e-06 0.0085599999999999999 -1.2925116887857888e-06 0.0085700000000000012 -1.2263298504084233e-05 0.0085800000000000008 2.6259909103188954e-06 0.0085900000000000004 5.4228547002799857e-06 0.0086 -3.7260057986717446e-06 0.0086100000000000013 6.0264611610086769e-06 0.0086200000000000009 1.0597026803824375e-05 0.0086300000000000005 5.9451859887585077e-06 0.0086400000000000001 -3.0004287966645494e-06 0.0086500000000000014 9.0114108942444941e-06 0.008660000000000001 7.0676552664764641e-07 0.0086700000000000006 -8.7830203211737603e-06 0.0086800000000000002 2.5289673467620711e-06 0.0086900000000000015 -2.7729693529482061e-06 0.0087000000000000011 -2.9553994246860812e-06 0.0087100000000000007 3.1419926051612665e-06 0.0087200000000000003 9.1775376288910911e-07 0.0087299999999999999 2.1693469535523651e-06 0.0087400000000000012 -2.4293106173813648e-06 0.0087500000000000008 7.0922755604323757e-06 0.0087600000000000004 1.19873250801318e-05 0.00877 -9.8521654543079512e-07 0.0087800000000000013 -3.1437310728618494e-06 0.0087900000000000009 2.1551102297088769e-06 0.0088000000000000005 -7.2263234619980192e-06 0.0088100000000000001 1.2121319764002533e-05 0.0088200000000000014 -1.1467928195932264e-05 0.008830000000000001 7.5987023121898884e-06 0.0088400000000000006 1.4262966871996634e-06 0.0088500000000000002 4.0218313210750367e-06 0.0088600000000000016 -7.7933052803304497e-07 0.0088700000000000011 3.461254049206617e-06 0.0088800000000000007 -4.1560898489288662e-07 0.0088900000000000003 1.1369292868519934e-06 0.0088999999999999999 -5.3412300362791828e-06 0.0089100000000000013 -3.2025593755750216e-06 0.0089200000000000008 -1.5625468783490564e-06 0.0089300000000000004 -3.4217881475584148e-06 0.00894 -4.5260210877468271e-07 0.0089500000000000014 1.3818036237620711e-06 0.0089600000000000009 2.0794230230363154e-07 0.0089700000000000005 8.0473545857263199e-06 0.0089800000000000001 -5.1418374289965481e-06 0.0089900000000000015 -1.6059218303193642e-06 0.0090000000000000011 -4.8910819222348186e-06 0.0090100000000000006 -7.6667288332000545e-06 0.0090200000000000002 -6.2284406674366436e-06 0.0090300000000000016 -4.3233012697062273e-06 0.0090400000000000012 -8.0089516361285248e-06 0.0090500000000000008 1.1006513733541419e-06 0.0090600000000000003 -3.9028989900441307e-06 0.0090699999999999999 1.5048903947047853e-06 0.0090800000000000013 -6.1157773195411265e-06 0.0090900000000000009 1.5469310414949699e-06 0.0091000000000000004 2.7227471053578018e-06 0.00911 -3.7460597881410317e-06 0.0091200000000000014 -2.7275179396384237e-06 0.009130000000000001 -5.1593939077877738e-06 0.0091400000000000006 5.3264059575417748e-06 0.0091500000000000001 -6.5173950762863073e-06 0.0091600000000000015 -2.5434413664703218e-06 0.0091700000000000011 -3.1260954363300811e-06 0.0091800000000000007 4.388578766808366e-06 0.0091900000000000003 5.1759824033087332e-06 0.0092000000000000016 -4.6313675127738325e-06 0.0092100000000000012 -6.308940906532277e-07 0.0092200000000000008 -1.8656423790285948e-06 0.0092300000000000004 2.1099914167887604e-06 0.0092399999999999999 1.3031678555783941e-07 0.0092500000000000013 3.2368081742918684e-06 0.0092600000000000009 9.3888654361404597e-07 0.0092700000000000005 -4.4173888469608664e-06 0.0092800000000000001 1.1051230762173968e-06 0.0092900000000000014 6.5496224537431596e-06 0.009300000000000001 -2.3914219764999051e-06 0.0093100000000000006 -1.3837134859124771e-06 0.0093200000000000002 1.4468712238902676e-06 0.0093300000000000015 -4.9454896371454465e-06 0.0093400000000000011 1.8228198421116458e-06 0.0093500000000000007 7.5394321715853617e-06 0.0093600000000000003 -2.0053000066151212e-06 0.0093700000000000016 3.2966983434339906e-06 0.0093800000000000012 4.7011421177341192e-06 0.0093900000000000008 9.1465851559555441e-06 0.0094000000000000004 1.6502991723757231e-06 0.00941 5.7591174481554443e-06 0.0094200000000000013 3.2675754088487416e-07 0.0094300000000000009 -1.4828197707132946e-07 0.0094400000000000005 -7.9679591603396016e-06 0.0094500000000000001 8.6554841332186246e-06 0.0094600000000000014 7.9692225501266049e-06 0.009470000000000001 8.4084238112212803e-07 0.0094800000000000006 4.206775544866443e-06 0.0094900000000000002 -4.3458468412143687e-06 0.0095000000000000015 -2.8569781886405307e-07 0.0095100000000000011 -1.2255631866551605e-05 0.0095200000000000007 1.9933180303897741e-07 0.0095300000000000003 -4.5175790250592002e-06 0.0095400000000000016 1.8753658506042276e-06 0.0095500000000000012 5.429945556648092e-06 0.0095600000000000008 4.4488343032547885e-06 0.0095700000000000004 6.9827661454293786e-06 0.00958 -1.9431047879429156e-06 0.0095900000000000013 -3.2799271793059849e-06 0.0096000000000000009 -3.8920294315190896e-06 0.0096100000000000005 2.1482805486366494e-06 0.0096200000000000001 -1.1113489389080359e-05 0.0096300000000000014 -5.0454731357970536e-06 0.009640000000000001 1.2743045929727869e-05 0.0096500000000000006 -2.4380580975744335e-06 0.0096600000000000002 5.506715930231894e-06 0.0096700000000000015 -7.3335600235906555e-06 0.0096800000000000011 -3.5592615368413881e-06 0.0096900000000000007 3.5862058518014141e-06 0.0097000000000000003 -2.6271002160639367e-06 0.0097100000000000016 4.8841193641921671e-06 0.0097200000000000012 -7.1146985249672684e-06 0.0097300000000000008 7.415024931358046e-06 0.0097400000000000004 1.792134074138944e-06 0.00975 2.6963145951597382e-06 0.0097600000000000013 7.3452891749984008e-06 0.0097700000000000009 -1.3212197782504036e-06 0.0097800000000000005 4.2968110990625778e-06 0.0097900000000000001 1.0085108010836832e-05 0.0098000000000000014 3.9547252477292388e-06 0.009810000000000001 -5.0744247929690017e-06 0.0098200000000000006 7.7328702853197717e-06 0.0098300000000000002 -6.7228409469208946e-06 0.0098400000000000015 8.6740957708766912e-06 0.0098500000000000011 -1.7125094757419211e-06 0.0098600000000000007 -3.4706275423655138e-06 0.0098700000000000003 -2.5212807804121532e-06 0.0098800000000000016 4.2857507907964966e-07 0.0098900000000000012 5.8808393292465937e-06 0.0099000000000000008 1.9213155107648096e-06 0.0099100000000000004 -1.1214714248556139e-06 0.00992 3.3763393185678872e-06 0.0099300000000000013 5.1454483257625928e-06 0.0099400000000000009 -9.393575933767682e-06 0.0099500000000000005 2.2462871160178062e-06 0.0099600000000000001 1.381613314347133e-06 0.0099700000000000014 -7.7396866679004549e-07 0.009980000000000001 6.6001215468283812e-07 0.0099900000000000006 1.0485769646684882e-06 0.01 2.4571641635316323e-06 0.010010000000000002 6.244667984204702e-06 0.010020000000000001 -4.8030846573304144e-06 0.010030000000000001 3.1864236165052363e-06 0.01004 7.1892987242370802e-06 0.010050000000000002 -4.2289105460296498e-06 0.010060000000000001 -3.4553333052134826e-06 0.010070000000000001 5.8088922805349999e-06 0.01008 -2.3369081925244918e-06 0.01009 -5.689902010488611e-07 0.010100000000000001 -3.6921356533291242e-06 0.010110000000000001 1.3443840694670564e-06 0.010120000000000001 -3.7054316223701164e-06 0.01013 -1.5034626379080271e-06 0.010140000000000001 1.1091732738226529e-05 0.010150000000000001 5.0321089509572164e-07 0.010160000000000001 3.3337757244112203e-06 0.01017 7.3820823893927696e-06 0.010180000000000002 -3.1770055518391307e-06 0.010190000000000001 2.0430051817371683e-06 0.010200000000000001 5.0821203689828498e-06 0.01021 -3.3278414435715861e-06 0.010220000000000002 -2.102310675803894e-06 0.010230000000000001 5.7420054257526107e-06 0.010240000000000001 8.4997944135197075e-06 0.01025 -2.6980298847911468e-06 0.01026 -1.5295176640944806e-05 0.010270000000000001 1.8019746512414392e-06 0.010280000000000001 6.1250206992615193e-06 0.010290000000000001 -3.0337135750994625e-06 0.0103 -2.5906469736696442e-06 0.010310000000000001 -2.7688850154621897e-06 0.010320000000000001 -7.2014374431672295e-06 0.010330000000000001 -2.3602475534166689e-06 0.01034 -9.3778598615311375e-06 0.010350000000000002 -1.8929389764669973e-06 0.010360000000000001 -2.865187187381213e-06 0.010370000000000001 1.623025628899165e-06 0.01038 3.8243763468528958e-06 0.010390000000000002 -6.3959222356763019e-06 0.010400000000000001 -6.1989683848225909e-06 0.010410000000000001 -6.729097796545001e-06 0.01042 7.7939976045810663e-07 0.01043 -9.8735802545288945e-06 0.010440000000000001 -9.8523844078735762e-06 0.010450000000000001 1.3415765863686925e-06 0.010460000000000001 4.6533108297506882e-06 0.01047 1.5018685501915861e-07 0.010480000000000001 3.6889044359864144e-06 0.010490000000000001 4.4456906212903597e-06 0.010500000000000001 -1.9986343744911328e-06 0.01051 8.597559467125167e-06 0.010520000000000002 -3.1445206310541793e-06 0.010530000000000001 3.3489604352393949e-07 0.010540000000000001 6.7387684569596757e-07 0.01055 -8.3139085445487408e-06 0.010560000000000002 1.1580310094302503e-05 0.010570000000000001 -5.8647289154779611e-06 0.010580000000000001 -9.295065270289973e-06 0.01059 2.9358042576296864e-06 0.0106 9.7463171635088193e-07 0.010610000000000001 -4.0614253612340672e-06 0.010620000000000001 7.278389428620797e-07 0.010630000000000001 3.2762463521560994e-06 0.01064 7.0076645459264968e-06 0.010650000000000001 9.8715269459773321e-06 0.010660000000000001 -5.3037168343373245e-06 0.010670000000000001 2.6105934022220357e-06 0.01068 -7.9834588699590146e-06 0.010690000000000002 1.5097624357030476e-06 0.010700000000000001 -3.8889929575862147e-06 0.010710000000000001 9.2878429085108471e-07 0.01072 1.65034631994765e-06 0.010730000000000002 -5.9104906802102967e-06 0.010740000000000001 3.7807822570446816e-06 0.010750000000000001 -2.4861263292002279e-06 0.01076 -6.6324454146742027e-06 0.01077 7.225394244474907e-06 0.010780000000000001 -2.2998749654113784e-06 0.010790000000000001 -1.1624963531418825e-05 0.010800000000000001 8.58265620316485e-06 0.01081 -3.3610740488578824e-06 0.010820000000000001 -2.6094882277608096e-06 0.010830000000000001 -5.61349880347239e-06 0.010840000000000001 6.2233992785272358e-07 0.01085 6.1129715841975721e-06 0.010860000000000002 1.9854229607484573e-06 0.010870000000000001 8.8595207990791766e-06 0.010880000000000001 -1.9740052481984735e-07 0.01089 -2.696456210201029e-06 0.010900000000000002 -4.1775238323492642e-06 0.010910000000000001 3.0139335542790732e-06 0.010920000000000001 -8.1066249723392731e-06 0.01093 2.5197371382103043e-06 0.01094 -5.9228372779044456e-06 0.010950000000000001 -2.1149769347139828e-06 0.010960000000000001 -5.8128401284106987e-06 0.010970000000000001 2.5421991358103369e-06 0.01098 -1.1387503067628326e-05 0.010990000000000002 -4.7879339380295322e-06 0.011000000000000001 3.2045884280497506e-06 0.011010000000000001 -3.1216598960626803e-06 0.01102 3.8352093821961013e-06 0.011030000000000002 3.1211431046093319e-06 0.011040000000000001 3.3558096576931087e-06 0.011050000000000001 -5.5188625203724753e-06 0.01106 -7.3667994350796525e-06 0.011070000000000002 3.6792911990124565e-06 0.011080000000000001 -9.4831095373056138e-07 0.011090000000000001 -5.5943319315154522e-07 0.0111 6.8152135099377851e-06 0.01111 -2.8260630807339553e-07 0.011120000000000001 5.1977029748965499e-06 0.011130000000000001 4.8123132031673045e-06 0.011140000000000001 -1.0091521689664653e-05 0.01115 -3.4464257252274692e-06 0.011160000000000002 -3.0641021104680059e-06 0.011170000000000001 5.0720761383086804e-07 0.011180000000000001 -5.2310561647365142e-06 0.01119 -1.611087721802581e-06 0.011200000000000002 -8.5328700431706508e-06 0.011210000000000001 1.8903274963011801e-06 0.011220000000000001 -2.6194694085985263e-06 0.01123 -7.0850618792122254e-06 0.011240000000000002 2.3821036438752851e-06 0.011250000000000001 -2.9000656909308272e-06 0.011260000000000001 7.075498682513592e-06 0.011270000000000001 3.919464995075516e-06 0.01128 4.4507413696562998e-06 0.011290000000000001 8.6610265751219712e-06 0.011300000000000001 5.237702580796761e-06 0.011310000000000001 -6.2750309230503168e-06 0.01132 -7.6046397637209931e-06 0.011330000000000002 -9.1939784227617929e-06 0.011340000000000001 9.5287651018636846e-07 0.011350000000000001 -9.86497823554387e-06 0.01136 4.3432945677833122e-06 0.011370000000000002 8.3322786116167936e-06 0.011380000000000001 4.8359603961794946e-06 0.011390000000000001 -8.3719514752017665e-06 0.0114 -4.5306947385834785e-06 0.011410000000000002 -1.5245388804967516e-06 0.011420000000000001 3.1794242401751629e-06 0.011430000000000001 1.515911415985904e-06 0.011440000000000001 -6.1151745756358838e-06 0.01145 7.0437219954289191e-06 0.011460000000000001 5.0209422759210228e-06 0.011470000000000001 -2.2550728452440474e-06 0.011480000000000001 -1.8177467807556701e-06 0.01149 3.4324623328034111e-06 0.011500000000000002 6.5416825881527649e-07 0.011510000000000001 -7.4954580053668403e-06 0.011520000000000001 2.0839994114664399e-07 0.01153 -6.4543079986698241e-06 0.011540000000000002 2.2883841756208119e-06 0.011550000000000001 -3.9964226642294776e-07 0.011560000000000001 -2.3794160707437124e-06 0.01157 5.4768001124066726e-06 0.011580000000000002 7.5132747143864472e-07 0.011590000000000001 -8.4948987084078708e-08 0.011600000000000001 -1.9648456766071273e-06 0.011610000000000001 -6.0371400723259697e-07 0.01162 7.3887003978719577e-07 0.011630000000000001 -4.9177208520956844e-06 0.011640000000000001 -1.2559535902831358e-05 0.011650000000000001 4.7677507972702717e-06 0.01166 4.3755420802037166e-06 0.011670000000000002 -6.0509615721930296e-06 0.011680000000000001 -2.8195167404210012e-06 0.011690000000000001 -1.7419609083475688e-06 0.0117 -1.3147157870300808e-06 0.011710000000000002 -1.7139229153528919e-06 0.011720000000000001 3.4509309845693485e-06 0.011730000000000001 -1.385827323403498e-06 0.01174 -2.9701747374865828e-06 0.011750000000000002 2.1133097999987283e-06 0.011760000000000001 -3.6392539002057613e-06 0.011770000000000001 -3.6559417280594729e-06 0.011780000000000001 5.9569149392000545e-06 0.01179 -4.6023675583313708e-06 0.011800000000000001 6.0297453879619783e-06 0.011810000000000001 1.015870910777195e-07 0.011820000000000001 -5.6114624158880286e-06 0.01183 -1.3030260357959843e-06 0.011840000000000002 -4.489224486312934e-06 0.011850000000000001 1.1468723656354035e-06 0.011860000000000001 -5.77104245818727e-07 0.01187 -4.25539995284507e-07 0.011880000000000002 2.5087719900402483e-06 0.011890000000000001 5.5757406599594266e-06 0.011900000000000001 2.8842419303529528e-07 0.01191 4.2280971039367638e-06 0.011920000000000002 -3.4917852748191028e-06 0.011930000000000001 2.1086785531561059e-06 0.011940000000000001 7.6996579598695257e-06 0.011950000000000001 -8.9474828280992243e-07 0.01196 9.5415652847480513e-06 0.011970000000000001 -4.4044595330456657e-06 0.011980000000000001 -3.2764163438985319e-06 0.011990000000000001 -1.85997966012499e-06 0.012 -6.6107458566003511e-07 0.012010000000000002 -1.7119169484471423e-06 0.012020000000000001 7.7064169620921376e-06 0.012030000000000001 4.4847348416796475e-06 0.01204 4.9037033377890519e-07 0.012050000000000002 8.4027212136543006e-06 0.012060000000000001 5.8888205487578622e-06 0.012070000000000001 -4.9876153842624788e-06 0.01208 3.4750427896513915e-06 0.012090000000000002 9.3233305412749561e-06 0.012100000000000001 1.4256693606901417e-06 0.012110000000000001 4.7886189020754591e-06 0.012120000000000001 -1.0848495429519904e-05 0.01213 -3.708495436847507e-06 0.012140000000000001 2.7670102875518785e-06 0.012150000000000001 -7.1233835968754531e-06 0.012160000000000001 -3.13366177393275e-06 0.01217 1.3104161883037195e-05 0.012180000000000002 -3.1354853405331815e-06 0.012190000000000001 -3.1126873346816149e-06 0.012200000000000001 -3.9374169652578277e-06 0.01221 3.7654475084845905e-06 0.012220000000000002 -1.1008735146126603e-05 0.012230000000000001 -1.3887879848731871e-05 0.012240000000000001 -1.2888316830087144e-06 0.01225 4.9146809119441271e-06 0.012260000000000002 9.8477219957912186e-07 0.012270000000000001 -2.855674641223694e-06 0.012280000000000001 -6.7614043619284114e-07 0.012290000000000001 -5.9094525160027504e-06 0.0123 -3.299987379764716e-06 0.012310000000000001 9.8181760377058068e-06 0.012320000000000001 -8.163636795856805e-07 0.012330000000000001 5.5839247102542849e-07 0.01234 2.9648753263293445e-06 0.012350000000000002 -5.061560957703502e-06 0.012360000000000001 3.6877656811667765e-06 0.012370000000000001 -6.0823922929676259e-06 0.01238 5.1710891913351309e-07 0.012390000000000002 -2.4647656641087536e-06 0.012400000000000001 1.3174478931282042e-06 0.012410000000000001 1.5415724743048318e-06 0.01242 8.6531319514908664e-06 0.012430000000000002 3.2214791349092169e-06 0.012440000000000001 5.3522349554482744e-06 0.012450000000000001 8.5869711945209316e-06 0.012460000000000001 -2.3133196780802305e-06 0.01247 -4.5384981408515276e-06 0.012480000000000002 -2.8756023335521993e-06 0.012490000000000001 -7.2541492119278151e-07 0.012500000000000001 3.3474161516263247e-06 0.01251 -4.1390023798816859e-06 0.012520000000000002 2.9299727461761464e-06 0.012530000000000001 -7.241434392395977e-06 0.012540000000000001 -1.0650648838937542e-05 0.01255 -5.4487259959981118e-06 0.012560000000000002 -3.4606469554973525e-06 0.012570000000000001 3.4253025916379994e-06 0.012580000000000001 1.1524383864958874e-05 0.01259 7.8251682647498022e-06 0.012600000000000002 4.2474866192503231e-06 0.012610000000000001 -3.777080718755111e-08 0.012620000000000001 4.5998399059176516e-06 0.012630000000000001 -5.7377819412561631e-06 0.01264 -3.1604305637606144e-07 0.012650000000000002 -2.650465702543879e-08 0.012660000000000001 4.1937170680390167e-06 0.012670000000000001 -3.3926765282938761e-06 0.01268 8.5197095216200366e-07 0.012690000000000002 2.6291530356239551e-06 0.012700000000000001 5.0512334929597493e-06 0.012710000000000001 -3.4301655101006206e-06 0.01272 2.4092569487687002e-06 0.012730000000000002 -1.3966335754519134e-05 0.012740000000000001 9.7485725970421583e-07 0.012750000000000001 7.3690105491906791e-08 0.012760000000000001 9.5541474991626254e-06 0.012770000000000002 3.9023143420392867e-06 0.012780000000000001 2.6038782795321292e-06 0.012790000000000001 6.2014401229318567e-08 0.012800000000000001 -5.7293703080846982e-06 0.01281 -8.8950331907107802e-09 0.012820000000000002 1.378100747385146e-07 0.012830000000000001 3.9342018520650835e-10 0.012840000000000001 -4.9850017110485226e-07 0.01285 -3.8041925174308236e-06 0.012860000000000002 -2.8815147185658761e-06 0.012870000000000001 -2.1036564115667962e-06 0.012880000000000001 -5.3169714967210351e-06 0.01289 4.35977162755266e-06 0.012900000000000002 -4.1701521864705627e-06 0.012910000000000001 7.9614334188544015e-07 0.012920000000000001 -2.7083389981302705e-06 0.012930000000000001 5.4137744362029133e-06 0.012940000000000002 -4.4621641018828032e-07 0.012950000000000001 1.1355181747377261e-06 0.012960000000000001 -4.8883964969901735e-06 0.012970000000000001 -2.2758816482899932e-06 0.01298 7.4381550425969943e-06 0.012990000000000002 -8.7744323269677969e-06 0.013000000000000001 -4.1230193184052072e-06 0.013010000000000001 -6.1109167609541945e-06 0.01302 -8.6280609306243505e-06 0.013030000000000002 3.9861569969438627e-06 0.013040000000000001 -8.7824641789703411e-06 0.013050000000000001 -4.8360441432531905e-06 0.01306 -5.5861733558187387e-07 0.013070000000000002 -4.5726717620726832e-06 0.013080000000000001 4.4003792345913578e-06 0.013090000000000001 -8.6580745003827325e-07 0.013100000000000001 3.2629402813724781e-06 0.013110000000000002 -7.4403435391845492e-06 0.013120000000000001 7.8794133032511241e-06 0.013130000000000001 -5.9490191938935099e-08 0.013140000000000001 -7.5340654995371391e-06 0.01315 1.0699235882097623e-06 0.013160000000000002 4.6728177104555246e-06 0.013170000000000001 -1.0686171417794554e-06 0.013180000000000001 -2.176003925370677e-06 0.01319 -4.4794928047613909e-06 0.013200000000000002 5.6951005378628839e-06 0.013210000000000001 1.9592402907325548e-06 0.013220000000000001 2.1397154317123291e-06 0.01323 5.1808390686962131e-06 0.013240000000000002 7.580903714021797e-06 0.013250000000000001 -9.4416801885069396e-07 0.013260000000000001 6.3243279726600936e-06 0.013270000000000001 5.3401031123726244e-06 0.013280000000000002 -4.3637918574234166e-06 0.013290000000000001 5.2651710623782045e-07 0.013300000000000001 -7.5743142944595035e-06 0.013310000000000001 6.3617905246602365e-06 0.01332 -4.0451434750872841e-06 0.013330000000000002 -5.435134190029877e-06 0.013340000000000001 -2.8119814009004763e-06 0.013350000000000001 3.2147932152672005e-06 0.01336 2.9613302459829972e-06 0.013370000000000002 3.9513614804070358e-06 0.013380000000000001 8.3523555482969782e-06 0.013390000000000001 3.8581458156929591e-07 0.0134 -4.5739036654085786e-06 0.013410000000000002 -4.2285853941414412e-07 0.013420000000000001 -2.813201641030937e-06 0.013430000000000001 -3.13702733477134e-06 0.013440000000000001 -2.4861052265422791e-07 0.013450000000000002 -3.3895455995096837e-06 0.013460000000000001 -8.2349867575962888e-07 0.013470000000000001 1.54097703073326e-06 0.013480000000000001 -4.877695381201587e-06 0.01349 1.7717871127199658e-07 0.013500000000000002 3.8840587002307465e-06 0.013510000000000001 7.4356412005795543e-06 0.013520000000000001 5.5635438630739627e-06 0.01353 -4.7485158990511342e-06 0.013540000000000002 2.7380567921915854e-06 0.013550000000000001 4.1030906518275633e-07 0.013560000000000001 -8.4855266663620323e-06 0.01357 2.0307396377476988e-06 0.013580000000000002 -3.916856740103552e-07 0.013590000000000001 -6.7856056293056136e-06 0.013600000000000001 -7.6944483298833849e-06 0.013610000000000001 3.5609892490972963e-06 0.013620000000000002 -8.7742657356801775e-06 0.013630000000000001 -8.7503072480750767e-06 0.013640000000000001 2.9187436165892723e-06 0.013650000000000001 -1.1148704621999214e-05 0.01366 -1.5409655234560304e-06 0.013670000000000002 -3.3791903782748387e-06 0.013680000000000001 2.3965442697603254e-06 0.013690000000000001 2.2410820231692229e-06 0.0137 -5.7227161889842931e-06 0.013710000000000002 -5.6381796669867021e-06 0.013720000000000001 6.977996541786426e-06 0.013730000000000001 -5.8343803412132458e-06 0.01374 2.5032141598014709e-06 0.013750000000000002 -1.560268481678088e-06 0.013760000000000001 4.5641703523115941e-06 0.013770000000000001 -2.0805671938916763e-07 0.013780000000000001 -1.6556167715062816e-06 0.013790000000000002 1.629806465679218e-06 0.013800000000000002 3.0417397422129301e-06 0.013810000000000001 1.7607110631407086e-06 0.013820000000000001 2.8640927964653078e-06 0.01383 -2.6031905497254145e-06 0.013840000000000002 9.9938196771916091e-06 0.013850000000000001 -4.5563569963259285e-06 0.013860000000000001 -7.7477109141987782e-06 0.01387 -3.5742101329947348e-07 0.013880000000000002 -1.6366919664262081e-06 0.013890000000000001 -1.3889099125068837e-06 0.013900000000000001 -5.4559929619261212e-07 0.01391 -1.245857692237156e-05 0.013920000000000002 2.933359635023118e-06 0.013930000000000001 3.8862617758391914e-06 0.013940000000000001 -2.3280602963221692e-06 0.013950000000000001 -3.0610725509627478e-06 0.013960000000000002 -2.0529938855877268e-06 0.013970000000000002 9.5697168229305058e-06 0.013980000000000001 4.0781158620719708e-06 0.013990000000000001 -5.9523683134736978e-06 0.014 -5.2597467154250055e-06 0.014010000000000002 3.9956199348338582e-06 0.014020000000000001 2.2136180650161598e-06 0.014030000000000001 3.276438462639944e-06 0.01404 -5.5300183824335576e-06 0.014050000000000002 -4.2437458970400304e-06 0.014060000000000001 -5.9834955044348233e-07 0.014070000000000001 7.5285972082486366e-06 0.014080000000000001 3.7276351441975464e-07 0.014090000000000002 -2.4154501682701655e-06 0.014100000000000001 -4.2036553581800158e-06 0.014110000000000001 3.1954203792638811e-06 0.014120000000000001 1.3677089276182887e-06 0.014130000000000002 -6.3181521637647523e-06 0.014140000000000002 3.1356758739909683e-06 0.014150000000000001 -5.3166794329737527e-06 0.014160000000000001 5.7068239915859923e-06 0.01417 2.4697367401882507e-06 0.014180000000000002 -4.6707088023692314e-06 0.014190000000000001 3.6435849230753093e-07 0.014200000000000001 1.198028404108838e-05 0.01421 6.0258200578143419e-06 0.014220000000000002 1.0948957561216871e-07 0.014230000000000001 -4.5158189212915313e-06 0.014240000000000001 -8.791290571820192e-06 0.014250000000000001 -2.3305209238248447e-06 0.014260000000000002 7.2388584368453819e-06 0.014270000000000001 -4.2690101323897512e-06 0.014280000000000001 -3.5513734863057448e-06 0.014290000000000001 -1.0248570286963533e-05 0.014300000000000002 1.5539579502361693e-06 0.014310000000000002 1.7195135800883336e-06 0.014320000000000001 -4.9706637646593939e-06 0.014330000000000001 4.9055847076025866e-06 0.01434 5.0740982425757313e-06 0.014350000000000002 -2.2905706337515311e-06 0.014360000000000001 7.2450513905520092e-06 0.014370000000000001 -2.735257887484915e-06 0.01438 1.7554238951490427e-07 0.014390000000000002 -5.1852666709780272e-06 0.014400000000000001 4.0869855455963895e-06 0.014410000000000001 4.2777777096891302e-06 0.014420000000000001 -9.2268089446637331e-06 0.014430000000000002 -4.7454215085748542e-06 0.014440000000000001 -8.7959527235412531e-06 0.014450000000000001 -1.0426456121337853e-06 0.014460000000000001 5.8250862228542248e-06 0.014470000000000002 1.8955475595800225e-06 0.014480000000000002 1.453652747178485e-06 0.014490000000000001 5.3684488728429854e-06 0.014500000000000001 7.0860852845732029e-07 0.01451 1.2690572371361096e-06 0.014520000000000002 7.0785510158442659e-06 0.014530000000000001 -1.3899317765944631e-06 0.014540000000000001 1.5055333455910572e-06 0.01455 1.5053842929823109e-06 0.014560000000000002 2.6291248504771918e-06 0.014570000000000001 2.4937918666337417e-06 0.014580000000000001 2.9396314453006863e-06 0.014590000000000001 -7.1628703242812217e-06 0.014600000000000002 -6.7628209562195315e-06 0.014610000000000001 4.0765250247849717e-06 0.014620000000000001 -1.1247176889227627e-05 0.014630000000000001 2.5032985081955709e-06 0.014640000000000002 -2.0452147600544978e-06 0.014650000000000002 8.7912043644424112e-06 0.014660000000000001 5.3465460679415448e-06 0.014670000000000001 6.9005761728305878e-07 0.01468 8.7132985236223952e-08 0.014690000000000002 5.7797503802200771e-06 0.014700000000000001 4.8474230993655028e-06 0.014710000000000001 -1.2157016603196575e-06 0.01472 -1.0818679269372904e-05 0.014730000000000002 7.0350324902260395e-06 0.014740000000000001 -1.1789310643320127e-05 0.014750000000000001 5.0399428884595539e-06 0.014760000000000001 2.2618764560167785e-06 0.014770000000000002 -3.7580488241173123e-06 0.014780000000000001 9.3821435945013254e-07 0.014790000000000001 4.0376786716703052e-06 0.014800000000000001 -1.8405192276880774e-06 0.014810000000000002 5.3965334227465624e-06 0.014820000000000002 -5.1746164884656717e-06 0.014830000000000001 -8.4533706384885083e-06 0.014840000000000001 5.4463737683324896e-07 0.01485 5.341940860104036e-06 0.014860000000000002 -8.4942582511756579e-07 0.014870000000000001 -4.6290314157494694e-06 0.014880000000000001 1.8209389319738517e-06 0.01489 8.3178516414880526e-06 0.014900000000000002 -9.5401116969804118e-07 0.014910000000000001 -2.3004944447388626e-06 0.014920000000000001 1.380256677455992e-05 0.014930000000000001 -3.0787221277924389e-06 0.014940000000000002 5.0371314959751069e-07 0.014950000000000001 2.1449650241988634e-06 0.014960000000000001 -7.0372048929507078e-06 0.014970000000000001 3.4717965516884483e-06 0.014980000000000002 2.4973945067190215e-06 0.014990000000000002 3.4724941211626629e-06 0.015000000000000001 -6.9207185440506193e-07 0.015010000000000001 -4.1817075622383833e-06 0.01502 8.7910868815694837e-07 0.015030000000000002 9.8452680064798643e-07 0.015040000000000001 8.8464210512524708e-06 0.015050000000000001 2.8094277096555033e-06 0.01506 -7.1259609658393485e-06 0.015070000000000002 1.5635007283977394e-06 0.015080000000000001 1.9989825479272577e-06 0.015090000000000001 2.2163968243255414e-06 0.015100000000000001 4.0847261488245777e-06 0.015110000000000002 3.376894872087052e-06 0.015120000000000001 -1.1421873117656523e-05 0.015130000000000001 -2.0489366637352167e-06 0.015140000000000001 1.3551573052740048e-06 0.015150000000000002 6.6204115509008593e-06 0.015160000000000002 5.3931424144242805e-06 0.015170000000000001 5.6358330348165051e-08 0.015180000000000001 1.3053868566139822e-06 0.01519 1.4906885707289448e-05 0.015200000000000002 -5.8759839726402748e-07 0.015210000000000001 -1.158326948535516e-07 0.015220000000000001 3.5428606028897845e-07 0.01523 5.0441465353178221e-07 0.015240000000000002 9.598615724492856e-06 0.015250000000000001 -6.2221063549642056e-06 0.015260000000000001 5.2750051490378575e-06 0.015270000000000001 2.3168068001761453e-06 0.015280000000000002 3.6737260295130689e-07 0.015290000000000002 -1.4921061396011308e-06 0.015300000000000001 8.2163473016071007e-06 0.015310000000000001 -3.785025836125924e-06 0.015320000000000002 5.6653762595531756e-06 0.015330000000000002 2.4441232911079564e-06 0.015340000000000001 -6.2984210916216604e-06 0.015350000000000001 3.9759810253282479e-06 0.015360000000000002 8.0619759347179047e-06 0.015370000000000002 1.1977626397501115e-06 0.015380000000000001 6.8567640139565229e-06 0.015390000000000001 7.9164899663535581e-06 0.0154 -1.832712376493067e-06 0.015410000000000002 -1.1796600287610674e-05 0.015420000000000001 6.0670121854446899e-06 0.015430000000000001 -9.6141762903793178e-06 0.015440000000000001 -4.2467724549732366e-06 0.015450000000000002 -1.0722472727164834e-05 0.015460000000000002 9.2302053907555996e-06 0.015470000000000001 1.2529964187990352e-05 0.015480000000000001 4.443532714406728e-06 0.015490000000000002 3.2708299650537695e-06 0.015500000000000002 -5.1197824191383386e-06 0.015510000000000001 -3.2926536565058691e-06 0.015520000000000001 -4.0749156410617517e-07 0.015530000000000002 1.7673595863934093e-06 0.015540000000000002 -7.6359151047210016e-07 0.015550000000000001 3.4502566090914502e-07 0.015560000000000001 -4.192106597631443e-07 0.015570000000000001 2.0711169315597186e-06 0.015580000000000002 -2.2193242441256276e-06 0.015590000000000001 3.0852136571348639e-07 0.015600000000000001 -1.6198930572777369e-06 0.015610000000000001 -3.6234210915681527e-06 0.015620000000000002 2.1980275785399028e-07 0.015630000000000002 1.0211434598891087e-06 0.015640000000000001 7.9418934661927929e-07 0.015650000000000001 2.0764019271960892e-07 0.01566 9.2008560745424035e-07 0.01567 -2.2725187676541503e-06 0.015680000000000003 -5.4734189312225318e-06 0.015690000000000003 -1.5937311554618732e-06 0.015700000000000002 -4.293457915962744e-06 0.015710000000000002 -6.9606147934430494e-07 0.015720000000000001 5.8971145032699033e-06 0.015730000000000001 -2.0316240753048064e-06 0.015740000000000001 4.4702298257184433e-06 0.01575 -2.6202531608351872e-06 0.01576 -1.1637688979691498e-05 0.015770000000000003 9.8921547414234826e-06 0.015780000000000002 -7.2647511409338848e-06 0.015790000000000002 -1.3612026333500094e-06 0.015800000000000002 -2.6272826299479017e-06 0.015810000000000001 -2.8488782751119278e-06 0.015820000000000001 -3.4580237949023526e-06 0.01583 7.8911395658290606e-06 0.01584 9.2514278508048762e-06 0.015850000000000003 -1.3489849402799828e-06 0.015860000000000003 -5.5733528988451423e-06 0.015870000000000002 -3.4422071737423265e-06 0.015880000000000002 -9.4219588584840467e-07 0.015890000000000001 -1.1439766252758331e-06 0.015900000000000001 -1.0468705742054586e-05 0.015910000000000001 -5.3294283120481838e-06 0.01592 -1.1255996957818533e-06 0.01593 -8.712968175919902e-06 0.015940000000000003 -3.654182478322608e-06 0.015950000000000002 -5.1827821433815264e-06 0.015960000000000002 -5.5763033493321306e-06 0.015970000000000002 3.3978507034612866e-06 0.015980000000000001 -1.6643916527493153e-06 0.015990000000000001 -8.5219384835571161e-06 0.016 -4.809874093098705e-06 0.01601 5.0070595203153398e-06 0.016020000000000003 3.5648560157034356e-06 0.016030000000000003 -2.2806767566062867e-07 0.016040000000000002 3.2062770947750392e-06 0.016050000000000002 -5.01199325337991e-06 0.016060000000000001 1.134988957730091e-05 0.016070000000000001 4.5557955547274923e-06 0.016080000000000001 7.1203448194062229e-06 0.01609 4.5983597339281247e-06 0.0161 7.1288144431432907e-07 0.016110000000000003 -6.6365337510179986e-06 0.016120000000000002 -4.5589656559477582e-06 0.016130000000000002 1.4247848589934013e-05 0.016140000000000002 -1.0264520004081646e-05 0.016150000000000001 -1.225982854418446e-06 0.016160000000000001 6.8163054044216894e-06 0.01617 -1.6211440027948735e-06 0.01618 4.1586467563999758e-06 0.016190000000000003 -1.1678068533342414e-06 0.016200000000000003 9.8411336132566649e-07 0.016210000000000002 -3.4642401549420577e-06 0.016220000000000002 1.4407626559493319e-06 0.016230000000000001 -1.922954115596145e-07 0.016240000000000001 4.5058058876707078e-06 0.016250000000000001 -7.9211162150570641e-06 0.01626 -4.8907421448736196e-06 0.01627 -1.9039226851181066e-06 0.016280000000000003 -8.0082638032747099e-06 0.016290000000000002 -1.3893795549220669e-06 0.016300000000000002 -5.0888740416236312e-06 0.016310000000000002 5.9159312020442612e-07 0.016320000000000001 1.7375971114862996e-07 0.016330000000000001 -9.9280381009882666e-06 0.01634 1.8079772642819419e-06 0.01635 6.3297117554027617e-06 0.016360000000000003 4.2530310288169134e-06 0.016370000000000003 -8.5731139913461567e-06 0.016380000000000002 2.866462316272065e-06 0.016390000000000002 -1.7737338110140978e-06 0.016400000000000001 3.7923258873624501e-06 0.016410000000000001 -7.3558139527222757e-06 0.016420000000000001 -1.4197373082650776e-06 0.01643 4.8071319712886241e-06 0.01644 -5.6948826556781578e-09 0.016450000000000003 -2.5536062382677839e-06 0.016460000000000002 -4.3657810609423353e-06 0.016470000000000002 6.8999885397128869e-07 0.016480000000000002 -3.0552226438869448e-06 0.016490000000000001 1.2105761600047627e-06 0.016500000000000001 -8.5110650896574376e-07 0.01651 -2.7298366796665809e-06 0.01652 -6.4790047172101609e-06 0.016530000000000003 -1.6325336569553801e-06 0.016540000000000003 3.512366769038042e-06 0.016550000000000002 8.6208841169064831e-06 0.016560000000000002 -3.1062038151903096e-06 0.016570000000000001 -5.591791103395611e-06 0.016580000000000001 6.4679094244826655e-06 0.016590000000000001 -1.2752889607281952e-07 0.0166 4.5034161471292964e-06 0.01661 -3.9165725244667948e-07 0.016620000000000003 4.7780533276500155e-06 0.016630000000000002 1.4362600548121907e-06 0.016640000000000002 -2.2967224446441191e-06 0.016650000000000002 -7.7784197852450907e-07 0.016660000000000001 -4.837448851995184e-07 0.016670000000000001 -2.9752486461315417e-06 0.01668 -5.3349542588718659e-06 0.01669 -1.8048129921839349e-06 0.016700000000000003 -2.7304916703231727e-06 0.016710000000000003 -3.3452227537486269e-07 0.016720000000000002 1.3717718591835332e-05 0.016730000000000002 3.1174810825581752e-06 0.016740000000000001 3.3664860603607853e-06 0.016750000000000001 4.3065342016623654e-06 0.016760000000000001 2.138679322411382e-06 0.01677 -2.9196582811873425e-06 0.01678 7.7770760148996532e-06 0.016790000000000003 4.6668870023088191e-06 0.016800000000000002 -2.0405433931204743e-06 0.016810000000000002 7.4222776581931973e-06 0.016820000000000002 -2.8647223509930388e-06 0.016830000000000001 -2.2640280526114154e-06 0.016840000000000001 5.8175399880580942e-06 0.01685 5.6502836361856144e-07 0.01686 2.2572289266314532e-06 0.016870000000000003 -1.409474893544024e-06 0.016880000000000003 9.5493661029041116e-07 0.016890000000000002 -9.5300788882504307e-07 0.016900000000000002 2.6805447558715636e-07 0.016910000000000001 -2.342161960186007e-06 0.016920000000000001 -1.6953768785553907e-06 0.016930000000000001 2.3975472862843371e-07 0.01694 -2.2130135479950129e-06 0.01695 -1.9599743618740909e-06 0.016960000000000003 5.0997724689627873e-07 0.016970000000000002 1.5077651608465705e-05 0.016980000000000002 2.959785947427564e-06 0.016990000000000002 3.2391121611055513e-06 0.017000000000000001 -4.7314951121218032e-07 0.017010000000000001 -4.2760404406797698e-07 0.01702 -2.103999855315093e-06 0.01703 1.8048352808687802e-06 0.017040000000000003 -9.0144470824809173e-06 0.017050000000000003 2.447051535114559e-06 0.017060000000000002 5.591796144127608e-06 0.017070000000000002 -4.853754853266505e-06 0.017080000000000001 -5.7452647763421598e-06 0.017090000000000001 -2.0378701103453576e-06 0.017100000000000001 -1.2044013117230949e-06 0.01711 3.539041757930578e-07 0.01712 -3.8998553889797157e-06 0.017130000000000003 -2.9729149671101881e-06 0.017140000000000002 -6.5160159308917461e-06 0.017150000000000002 1.8400253884599945e-06 0.017160000000000002 4.9603506130694697e-07 0.017170000000000001 -8.9268729044450582e-06 0.017180000000000001 2.0401929687523405e-06 0.01719 -3.5515111375623558e-07 0.0172 -2.0631902307453567e-06 0.017210000000000003 2.9975278384210648e-06 0.017220000000000003 -1.2682873885925972e-06 0.017230000000000002 -2.3371348661874485e-07 0.017240000000000002 -2.4425899378477376e-06 0.017250000000000001 -5.1636860702266803e-06 0.017260000000000001 4.1990605956651026e-06 0.017270000000000001 4.302116715439403e-06 0.01728 -4.2763184693469662e-07 0.01729 -4.2167616053259048e-06 0.017300000000000003 3.0091479957675883e-06 0.017310000000000002 -4.5575479567909635e-06 0.017320000000000002 2.0251667648224963e-06 0.017330000000000002 -2.8889471146659424e-06 0.017340000000000001 3.1135400214275265e-06 0.017350000000000001 -2.6473206644115534e-06 0.01736 7.1932234137040692e-06 0.01737 -6.232980913714234e-07 0.017380000000000003 -5.7822912465591852e-06 0.017390000000000003 7.314918463033951e-07 0.017400000000000002 -7.8993478835145317e-07 0.017410000000000002 3.123074026735362e-06 0.017420000000000001 2.708188527422645e-06 0.017430000000000001 7.3131394444309922e-06 0.017440000000000001 -3.9060038653982176e-06 0.01745 -5.695982295100265e-06 0.01746 -4.8488564465847272e-06 0.017470000000000003 2.9249509757990842e-06 0.017480000000000002 -2.26968760524763e-06 0.017490000000000002 4.3199420370834995e-06 0.017500000000000002 2.9342819780844662e-06 0.017510000000000001 6.1443772420615643e-06 0.017520000000000001 -5.9859128231767946e-06 0.01753 8.7639322359545767e-06 0.01754 -2.9476010522529062e-06 0.017550000000000003 2.1732283673247993e-06 0.017560000000000003 1.2013588309437729e-05 0.017570000000000002 -3.6383221149759856e-06 0.017580000000000002 -1.2248739951285439e-06 0.017590000000000001 -6.0151643190844275e-06 0.017600000000000001 5.983722881507135e-06 0.017610000000000001 -3.6972206390940096e-06 0.01762 2.4401053627942295e-07 0.01763 1.4734928321218791e-06 0.017640000000000003 -1.295815676861171e-06 0.017650000000000002 6.6703804351164249e-07 0.017660000000000002 -5.6103135817239484e-06 0.017670000000000002 -2.4924448493283769e-06 0.017680000000000001 6.2937537035485378e-06 0.017690000000000001 4.3923901610672111e-06 0.0177 2.8894634692227391e-06 0.01771 -1.6280365769522167e-06 0.017720000000000003 -3.6588306954371013e-06 0.017730000000000003 2.0040362996139624e-06 0.017740000000000002 2.4468964728238485e-06 0.017750000000000002 8.0761732638623269e-06 0.017760000000000001 1.0907057505542364e-06 0.017770000000000001 -1.3201939672813186e-06 0.017780000000000001 9.6011265983983278e-06 0.01779 1.6849199139230201e-06 0.0178 3.9394419067564451e-07 0.017810000000000003 8.6183815057779943e-06 0.017820000000000003 4.0184756829465341e-06 0.017830000000000002 -5.4716020698458685e-07 0.017840000000000002 2.8500340662135763e-06 0.017850000000000001 4.5419620863598236e-06 0.017860000000000001 -7.1875466214674917e-06 0.01787 -4.0115838919317715e-07 0.01788 9.5157437435583232e-08 0.017890000000000003 -4.0854051093644238e-07 0.017900000000000003 -7.5764814075083826e-06 0.017910000000000002 4.2611779691505287e-06 0.017920000000000002 4.4916638544117038e-06 0.017930000000000001 -3.7756894204222034e-06 0.017940000000000001 -4.8034571004915024e-07 0.017950000000000001 4.0218225295133732e-06 0.01796 -2.5014860162989008e-06 0.01797 1.03010575782023e-06 0.017980000000000003 5.5827546381237411e-07 0.017990000000000003 3.1673606459799534e-06 0.018000000000000002 2.1613449502268064e-06 0.018010000000000002 -6.6627102620005543e-07 0.018020000000000001 3.6597572514967989e-06 0.018030000000000001 5.4008982695126114e-06 0.01804 1.3609604432788301e-06 0.01805 2.9825468060127572e-06 0.018060000000000003 -9.8989400813096983e-07 0.018070000000000003 3.1772847670058182e-06 0.018080000000000002 5.3546941242362324e-06 0.018090000000000002 2.6089016620235941e-06 0.018100000000000002 9.5946793817810384e-06 0.018110000000000001 7.395460966159408e-06 0.018120000000000001 -5.1453222811096996e-06 0.01813 -3.8208270941756011e-06 0.01814 2.4821652961815463e-06 0.018150000000000003 -5.070082697061268e-07 0.018160000000000003 3.6895772309157711e-07 0.018170000000000002 -4.1997803753964712e-06 0.018180000000000002 -2.4726469504664599e-06 0.018190000000000001 5.2842448375110345e-06 0.018200000000000001 4.2737427452206154e-06 0.01821 5.1473286644467189e-06 0.01822 6.2642520224159822e-06 0.018230000000000003 -2.5726743938298764e-06 0.018240000000000003 -2.9679907567110746e-06 0.018250000000000002 -8.7975799682341813e-06 0.018260000000000002 -2.8899619949043083e-06 0.018270000000000002 5.5975305188415511e-06 0.018280000000000001 2.7914050039926838e-06 0.018290000000000001 -7.8549363642148145e-06 0.0183 9.0906309868050593e-07 0.01831 -5.1657512817050655e-06 0.018320000000000003 -3.5978143099389202e-06 0.018330000000000003 -3.1366124636291885e-06 0.018340000000000002 5.510931203936053e-08 0.018350000000000002 8.0191356953252297e-06 0.018360000000000001 7.4413444936002778e-07 0.018370000000000001 4.1688273404736298e-06 0.018380000000000001 -2.285924885606012e-07 0.01839 -1.4136202428278401e-06 0.018400000000000003 6.9362260276815399e-06 0.018410000000000003 4.8505178476696799e-06 0.018420000000000002 -4.1691452344847587e-06 0.018430000000000002 -4.6252076580559904e-06 0.018440000000000002 -8.3038398128980616e-06 0.018450000000000001 -5.4052609790593878e-06 0.018460000000000001 5.298133680399017e-07 0.01847 1.9239293534935102e-06 0.01848 4.100420991791882e-06 0.018490000000000003 -4.4818029565051842e-06 0.018500000000000003 -7.7709475124594264e-06 0.018510000000000002 -5.627705601681398e-06 0.018520000000000002 -7.8403348226536871e-06 0.018530000000000001 -1.5851396378696565e-06 0.018540000000000001 -2.3311223271199515e-06 0.018550000000000001 4.792977439527038e-06 0.01856 3.6506058962299602e-06 0.018570000000000003 -4.6107351966365799e-06 0.018580000000000003 -1.1867029685738572e-06 0.018590000000000002 -5.2237139008695222e-07 0.018600000000000002 5.6736829659981499e-07 0.018610000000000002 -4.1055627025339193e-06 0.018620000000000001 -2.3397033808370966e-06 0.018630000000000001 4.9291413361476124e-06 0.01864 -5.0761303196844771e-06 0.01865 4.8765641825156905e-06 0.018660000000000003 -7.2962313046400306e-06 0.018670000000000003 1.0351153218607488e-06 0.018680000000000002 -3.5177643206399204e-06 0.018690000000000002 -6.267948955239593e-06 0.018700000000000001 2.2635744512031663e-06 0.018710000000000001 3.7982556441409964e-06 0.018720000000000001 2.7623349624314532e-07 0.01873 2.7577222802496217e-06 0.018740000000000003 9.2814190368661054e-06 0.018750000000000003 2.9482887088355348e-06 0.018760000000000002 -5.8329367287998506e-06 0.018770000000000002 1.5132094993704939e-05 0.018780000000000002 4.7192024425553045e-06 0.018790000000000001 -7.7913075366263517e-06 0.018800000000000001 -1.500016333048004e-07 0.01881 -9.5211214494424481e-06 0.01882 1.9440167057057714e-06 0.018830000000000003 4.7185925353704801e-06 0.018840000000000003 -1.8084245615858675e-06 0.018850000000000002 2.455922810422165e-06 0.018860000000000002 -5.649416400153976e-06 0.018870000000000001 5.502487976460181e-06 0.018880000000000001 1.8184006365052155e-07 0.018890000000000001 6.9360295168097822e-06 0.0189 9.1905676808668817e-06 0.018910000000000003 -2.2933330465997573e-06 0.018920000000000003 -1.0743732118190975e-06 0.018930000000000002 -1.9233106268343649e-08 0.018940000000000002 -6.7762035918503224e-06 0.018950000000000002 9.3014905372853718e-06 0.018960000000000001 -8.1580203093667946e-07 0.018970000000000001 5.7472784144862713e-06 0.01898 -2.1574851755843369e-06 0.01899 4.0573702301450825e-06 0.019000000000000003 1.5775816678723677e-06 0.019010000000000003 -5.0820980307902172e-06 0.019020000000000002 -6.6717654423179891e-07 0.019030000000000002 -1.5769585946954202e-07 0.019040000000000001 1.66076342172145e-06 0.019050000000000001 -7.3504463800022972e-06 0.019060000000000001 1.4846506968263266e-06 0.01907 2.0329994858001043e-06 0.019080000000000003 3.3743276868205656e-06 0.019090000000000003 7.2562523472607747e-06 0.019100000000000002 -5.5558704837033408e-07 0.019110000000000002 3.1202791515220347e-06 0.019120000000000002 -5.7814288399124077e-07 0.019130000000000001 -1.9301099120805273e-06 0.019140000000000001 -6.2670615874888644e-06 0.01915 6.5255064911993725e-06 0.01916 -9.2319523625828371e-06 0.019170000000000003 1.0913329133804778e-06 0.019180000000000003 -5.6429075509002142e-06 0.019190000000000002 7.4947581244511373e-06 0.019200000000000002 2.0669226511057599e-06 0.019210000000000001 -4.5560399726150567e-06 0.019220000000000001 -6.2467324354338213e-06 0.019230000000000001 3.0521795033299105e-06 0.01924 5.1134212727391372e-06 0.019250000000000003 1.1737181132932979e-05 0.019260000000000003 -2.3960148147310764e-06 0.019270000000000002 2.079713716509622e-06 0.019280000000000002 8.2040999644198169e-06 0.019290000000000002 -5.168797175624154e-06 0.019300000000000001 -2.3061114438661949e-06 0.019310000000000001 -6.2002947163055363e-06 0.01932 -6.1505790036064419e-06 0.01933 3.3115849767993162e-07 0.019340000000000003 1.0043867796652507e-05 0.019350000000000003 -3.874948976382491e-06 0.019360000000000002 1.4417296521032376e-05 0.019370000000000002 3.2319374003502685e-06 0.019380000000000001 2.6912566439186677e-06 0.019390000000000001 -3.3853759935069681e-06 0.019400000000000001 6.1305045964682933e-06 0.01941 -7.5991304162749789e-07 0.019420000000000003 2.5345722199631717e-06 0.019430000000000003 -6.9154305703460769e-06 0.019440000000000002 2.6143895847535495e-06 0.019450000000000002 -9.2093423685111687e-06 0.019460000000000002 1.0834196192295997e-05 0.019470000000000001 -4.1050805656023805e-07 0.019480000000000001 7.8073358131686229e-08 0.01949 -6.0615530099709094e-07 0.0195 6.5855291898503463e-06 0.019510000000000003 -6.3360345621950499e-07 0.019520000000000003 5.6917232578335787e-06 0.019530000000000002 -3.1278712510895976e-06 0.019540000000000002 8.9552901754312618e-06 0.019550000000000001 -1.9289593423734693e-06 0.019560000000000001 -2.0267074370363163e-06 0.019570000000000001 8.0980440283580546e-06 0.01958 2.9872948891671049e-06 0.019590000000000003 7.0833335642933235e-07 0.019600000000000003 -4.7040124851317819e-06 0.019610000000000002 -7.6858558738992003e-07 0.019620000000000002 -1.3032432524936809e-05 0.019630000000000002 1.2191106211206861e-06 0.019640000000000001 6.7290126900864132e-07 0.019650000000000001 -3.5628934589134768e-06 0.01966 -4.4745407068206557e-06 0.01967 1.8472979951092839e-06 0.019680000000000003 2.2472520281232993e-06 0.019690000000000003 -3.9434114624371889e-06 0.019700000000000002 3.2902482248567915e-06 0.019710000000000002 -7.2378862461059014e-07 0.019720000000000001 -7.0444693163070767e-06 0.019730000000000001 1.9082231628566143e-06 0.019740000000000001 -2.4756857253654639e-06 0.01975 -2.4408601139983938e-06 0.019760000000000003 2.34555763691962e-06 0.019770000000000003 -5.7467058171611546e-06 0.019780000000000002 -2.9327371840125023e-06 0.019790000000000002 -1.2568077261401457e-06 0.019800000000000002 4.7884213820540149e-06 0.019810000000000001 4.7364051786625627e-06 0.019820000000000001 2.0270228613029338e-06 0.01983 -5.8839264221963236e-06 0.01984 -4.1668232660625254e-06 0.019850000000000003 2.7226647476683525e-06 0.019860000000000003 6.3104998588646861e-06 0.019870000000000002 1.4865640432582059e-06 0.019880000000000002 7.5068340290882976e-06 0.019890000000000001 -1.2445305709901417e-06 0.019900000000000001 -6.638527263101973e-06 0.019910000000000001 -1.5484229157108128e-06 0.01992 -2.4410497056507248e-06 0.019930000000000003 -3.14544113882511e-06 0.019940000000000003 -3.7733087447744582e-06 0.019950000000000002 -4.1488628918466903e-06 0.019960000000000002 8.3137391364111629e-07 0.019970000000000002 -1.0372784171550817e-05 0.019980000000000001 7.3422805024952591e-06 0.019990000000000001 -4.7102327475088519e-07 0.02 5.1147994688052114e-06 0.02001 4.2584405035590873e-06 0.020020000000000003 -7.8768978522863024e-06 0.020030000000000003 -6.5745468425935081e-06 0.020040000000000002 3.5712993052486691e-07 0.020050000000000002 -1.2220071987481088e-06 0.020060000000000001 -3.1187943553821796e-06 0.020070000000000001 7.6626639688538093e-06 0.020080000000000001 -5.8890394212978833e-06 0.02009 7.2731101534098587e-07 0.020100000000000003 -3.1161314065922364e-06 0.020110000000000003 -6.923752939665604e-07 0.020120000000000002 -7.2340073102571373e-06 0.020130000000000002 7.6448451126225745e-06 0.020140000000000002 -1.0456919649411638e-06 0.020150000000000001 1.216074593414505e-06 0.020160000000000001 5.2178856900768297e-07 0.02017 1.9137939787412531e-06 0.02018 8.7914793558306905e-06 0.020190000000000003 -3.3109171545128078e-06 0.020200000000000003 6.9803500270896476e-06 0.020210000000000002 4.0503310870758397e-06 0.020220000000000002 -2.3121275015845302e-06 0.020230000000000001 8.5416794739309132e-06 0.020240000000000001 6.0644932422364573e-07 0.020250000000000001 -2.6325143103425395e-06 0.02026 -2.5903562150003252e-06 0.020270000000000003 6.5076607224063979e-06 0.020280000000000003 -2.7262821004033045e-06 0.020290000000000002 -1.2941515450425858e-06 0.020300000000000002 -5.862351675295545e-07 0.020310000000000002 -1.3004661353850978e-05 0.020320000000000001 2.1970489574502394e-06 0.020330000000000001 6.9813473867860166e-07 0.02034 5.303171827371859e-07 0.02035 -7.1655460589541803e-07 0.020360000000000003 -1.7765702632379782e-06 0.020370000000000003 1.5244336518214034e-06 0.020380000000000002 6.156217450614597e-06 0.020390000000000002 -7.9795045371208426e-07 0.020400000000000001 1.0668106964099126e-06 0.020410000000000001 4.0671709838569654e-07 0.020420000000000001 4.5303771392433179e-06 0.02043 8.263440402176704e-06 0.020440000000000003 6.6455162468212552e-06 0.020450000000000003 6.7328581450771382e-08 0.020460000000000002 -5.7749449067019494e-06 0.020470000000000002 5.9143577076892276e-07 0.020480000000000002 -4.9146599695569128e-06 0.020490000000000001 -3.1862168137350391e-06 0.020500000000000001 3.5929411204012628e-06 0.02051 -1.4351336760317411e-06 0.02052 8.9526980516718484e-06 0.020530000000000003 -1.6436008696204153e-06 0.020540000000000003 -1.7719529836502873e-06 0.020550000000000002 -1.2003806550918467e-06 0.020560000000000002 2.457209492932463e-08 0.020570000000000001 -9.9434262396506792e-06 0.020580000000000001 2.115675253084056e-06 0.020590000000000001 -4.9450679367264926e-06 0.0206 -2.2722239272578708e-06 0.020610000000000003 -4.3417686220865451e-06 0.020620000000000003 6.9376028437274324e-06 0.020630000000000003 -5.5945570430415604e-06 0.020640000000000002 -3.7842672113692484e-06 0.020650000000000002 -9.8282955862189774e-07 0.020660000000000001 -4.1588336576039097e-07 0.020670000000000001 8.3902224172806159e-07 0.02068 -1.5291560884938984e-07 0.02069 7.435536022350383e-07 0.020700000000000003 8.4739224457566099e-06 0.020710000000000003 4.3875800056736304e-06 0.020720000000000002 3.869219860852801e-06 0.020730000000000002 -4.3447241006023673e-06 0.020740000000000001 1.3401964176291199e-06 0.020750000000000001 6.7251505045069488e-07 0.020760000000000001 -1.0832608494442519e-05 0.02077 5.8353023218825153e-06 0.020780000000000003 -2.5059971716732085e-06 0.020790000000000003 -7.5871503759703578e-07 0.020800000000000003 3.5415230932000773e-06 0.020810000000000002 -2.246228758897673e-07 0.020820000000000002 3.1712552610862773e-06 0.020830000000000001 -8.5870939640638494e-06 0.020840000000000001 2.8130440380271083e-06 0.02085 -1.0450725321950166e-05 0.02086 6.5777370910391436e-06 0.020870000000000003 -1.6996672287317697e-06 0.020880000000000003 -4.5112381893106269e-06 0.020890000000000002 6.5283051051238489e-07 0.020900000000000002 -3.4802503417745266e-06 0.020910000000000002 -2.0998696350320984e-06 0.020920000000000001 -3.6327163936799074e-06 0.020930000000000001 -8.7903672161160209e-06 0.02094 -6.7666439694076993e-06 0.020950000000000003 -5.0040973014620983e-06 0.020960000000000003 -3.9240889388134436e-06 0.020970000000000003 2.7183683482405091e-06 0.020980000000000002 1.3562327693695795e-06 0.020990000000000002 -4.8312237706289974e-06 0.021000000000000001 8.8261501768016819e-06 0.021010000000000001 -4.7440083958455556e-06 0.02102 4.7994337885797368e-06 0.02103 -3.8540960591362726e-06 0.021040000000000003 3.8985084466847833e-06 0.021050000000000003 3.1371055339889254e-06 0.021060000000000002 -2.2905589578594168e-06 0.021070000000000002 3.738364340128358e-06 0.021080000000000002 -7.8477641970651691e-06 0.021090000000000001 2.2270171303925702e-06 0.021100000000000001 -1.6081405462745674e-06 0.02111 1.0167808328687054e-05 0.021120000000000003 -3.0262926784566855e-06 0.021130000000000003 -3.8015528635849313e-06 0.021140000000000003 -1.9720076190248487e-06 0.021150000000000002 1.8799604855332074e-05 0.021160000000000002 -9.2064139983402745e-07 0.021170000000000001 6.4302607968919744e-07 0.021180000000000001 -1.9682089076120697e-06 0.021190000000000001 -8.6811583851505035e-06 0.0212 3.5867366254414727e-08 0.021210000000000003 -5.2249376572385044e-06 0.021220000000000003 5.4881128982238971e-07 0.021230000000000002 1.9371616257432053e-08 0.021240000000000002 -1.370648897308923e-06 0.021250000000000002 2.2117337174904238e-06 0.021260000000000001 7.1625216269260322e-06 0.021270000000000001 -6.2130911840875951e-06 0.02128 2.8137676140411845e-06 0.021290000000000003 -2.4051862063423339e-06 0.021300000000000003 -1.2321070444114085e-06 0.021310000000000003 -2.8529584789353907e-06 0.021320000000000002 6.3185182839266982e-06 0.021330000000000002 -1.7829593309740946e-06 0.021340000000000001 1.2501645960163564e-06 0.021350000000000001 1.5877669114479402e-06 0.021360000000000001 -8.1650737393136513e-07 0.02137 -1.3322306279819739e-06 0.021380000000000003 7.8809889779268873e-07 0.021390000000000003 2.9568406693190615e-06 0.021400000000000002 5.797818530484778e-06 0.021410000000000002 -2.4324399414129232e-06 0.021420000000000002 4.3915268614447212e-07 0.021430000000000001 7.1554969064755344e-06 0.021440000000000001 2.6352654634585372e-06 0.02145 9.7506175710980506e-06 0.021460000000000003 2.1975316423046027e-06 0.021470000000000003 4.4616550212464547e-07 0.021480000000000003 1.2537214734888799e-06 0.021490000000000002 -8.9988558184755852e-06 0.021500000000000002 -2.1481530133357263e-06 0.021510000000000001 1.0855709923201421e-07 0.021520000000000001 -4.1716509955319519e-07 0.021530000000000001 -4.8438736620537695e-06 0.02154 -8.9197720390501097e-07 0.021550000000000003 5.4764097663445195e-06 0.021560000000000003 -2.2618264247491721e-06 0.021570000000000002 2.2033661848045925e-06 0.021580000000000002 4.4640102685416601e-07 0.021590000000000002 -3.4446154351377074e-06 0.021600000000000001 7.2909028860490157e-06 0.021610000000000001 -5.9031920747670514e-06 0.02162 9.2749972951944855e-07 0.021630000000000003 -7.988812755946236e-06 0.021640000000000003 2.793971716833531e-06 0.021650000000000003 -6.9809573988020373e-06 0.021660000000000002 -2.0577863163853245e-06 0.021670000000000002 6.8210094490297326e-07 0.021680000000000001 -1.8684773301702546e-06 0.021690000000000001 1.2716159629671274e-05 0.021700000000000001 -6.916066160131583e-06 0.02171 6.6157782758524992e-06 0.021720000000000003 -2.0857567618468319e-06 0.021730000000000003 -1.1022140085753865e-06 0.021740000000000002 1.1690849860854212e-05 0.021750000000000002 6.2260813666493379e-06 0.021760000000000002 5.8687311954060845e-07 0.021770000000000001 1.7013264355702645e-06 0.021780000000000001 1.1952687924338198e-05 0.02179 -1.0880794754437838e-06 0.021800000000000003 9.9440113024152428e-07 0.021810000000000003 -2.4858153460057992e-06 0.021820000000000003 4.4684013094223652e-06 0.021830000000000002 2.4837252592237301e-06 0.021840000000000002 5.9933540484241893e-06 0.021850000000000001 2.383858003462679e-06 0.021860000000000001 8.0589034754152291e-06 0.021870000000000001 1.3363808165159425e-06 0.02188 -1.125064061255225e-06 0.021890000000000003 -2.3550199364055549e-06 0.021900000000000003 -3.6140642738809424e-08 0.021910000000000002 -6.8721237168847033e-07 0.021920000000000002 4.6802642836006667e-07 0.021930000000000002 1.2335163312720648e-06 0.021940000000000001 1.7875392849788749e-06 0.021950000000000001 1.5005641981282419e-06 0.02196 -4.4744803769288073e-06 0.021970000000000003 6.6321932663048308e-06 0.021980000000000003 1.8946104301762787e-06 0.021990000000000003 -7.6583009605688107e-06 0.022000000000000002 7.6969268248550398e-07 0.022010000000000002 4.2721239768134323e-07 0.022020000000000001 -9.1743498321908161e-06 0.022030000000000001 -4.1932565731670663e-06 0.022040000000000001 5.4020091748097122e-07 0.02205 -3.4165052108842417e-06 0.022060000000000003 5.2167424296963289e-06 0.022070000000000003 4.8217106838813008e-07 0.022080000000000002 -4.469121652890774e-06 0.022090000000000002 -8.0160227044281533e-06 0.022100000000000002 4.8303097020462412e-06 0.022110000000000001 -3.7696575752809855e-07 0.022120000000000001 -1.13059489696605e-07 0.02213 9.0007429700683144e-07 0.022140000000000003 8.7020947173694329e-06 0.022150000000000003 4.2015723867866695e-07 0.022160000000000003 1.6794665276496954e-06 0.022170000000000002 8.4045850559308524e-06 0.022180000000000002 1.2980248485822217e-06 0.022190000000000001 -5.2800128348317838e-06 0.022200000000000001 7.3331217614795704e-06 0.022210000000000001 7.6364888673498602e-06 0.02222 4.9016017491996263e-07 0.022230000000000003 9.1102339788960514e-06 0.022240000000000003 -2.1053701986622899e-06 0.022250000000000002 -1.2312662300682e-06 0.022260000000000002 -9.4172046844733989e-06 0.022270000000000002 -4.5601162475096571e-06 0.022280000000000001 -3.8700751734677918e-06 0.022290000000000001 1.5262501844014272e-06 0.0223 6.2245634569278078e-06 0.022310000000000003 -7.214556859483537e-06 0.022320000000000003 -5.885081266683981e-06 0.022330000000000003 -2.1623665060518038e-06 0.022340000000000002 7.9351215248030476e-06 0.022350000000000002 7.0467411442879497e-06 0.022360000000000001 4.0740716080900608e-06 0.022370000000000001 -7.4238348244718652e-06 0.022380000000000001 -4.7820571799697893e-06 0.02239 -5.9275621816505778e-06 0.022400000000000003 -3.1548499956371187e-06 0.022410000000000003 9.4257272870375454e-06 0.022420000000000002 -2.8307097141286865e-06 0.022430000000000002 -5.5439895043068782e-07 0.022440000000000002 7.1087676353186106e-06 0.022450000000000001 -8.0336771567408662e-06 0.022460000000000001 -6.820727663896242e-06 0.02247 -3.4556161713437449e-06 0.022480000000000003 -4.8161192539886689e-07 0.022490000000000003 5.3985453108081976e-06 0.022500000000000003 -4.2198928166952677e-06 0.022510000000000002 3.9288653658040234e-06 0.022520000000000002 1.1805057453424012e-06 0.022530000000000001 7.4857600869406096e-06 0.022540000000000001 2.4831558561620693e-06 0.022550000000000001 9.3783646429138614e-06 0.02256 -6.8409974595262086e-06 0.022570000000000003 4.0993379205187548e-07 0.022580000000000003 -8.3179438148883444e-07 0.022590000000000002 -6.2783058119782999e-06 0.022600000000000002 7.6093725245762596e-06 0.022610000000000002 -5.3373113342594948e-06 0.022620000000000001 9.6075478811230428e-06 0.022630000000000001 -5.8747364073608329e-06 0.02264 -3.9868473208075705e-07 0.022650000000000003 -3.972483787348866e-06 0.022660000000000003 -7.3212056479126578e-06 0.022670000000000003 -7.6464874235554115e-08 0.022680000000000002 1.7448438875919989e-07 0.022690000000000002 -4.5678404485586308e-06 0.022700000000000001 -1.2008565261545702e-06 0.022710000000000001 4.3392185674350421e-06 0.022720000000000001 7.9514961429951201e-07 0.02273 4.6869585661390879e-06 0.022740000000000003 -4.7061810582252951e-06 0.022750000000000003 3.9603690125824445e-06 0.022760000000000002 -6.1899427109345102e-06 0.022770000000000002 1.2963542872699423e-06 0.022780000000000002 3.9003034665120613e-06 0.022790000000000001 -1.4055737262389593e-06 0.022800000000000001 -1.2689652900996154e-06 0.02281 4.8865661963143389e-07 0.022820000000000003 -1.0117104493025618e-05 0.022830000000000003 -3.4323886981844777e-06 0.022840000000000003 -8.5682437397431331e-07 0.022850000000000002 -1.0798292974350521e-06 0.022860000000000002 1.2119493697743739e-06 0.022870000000000001 -1.2508645492202309e-06 0.022880000000000001 -3.4647569977541473e-06 0.022890000000000001 8.5201116690111315e-07 0.0229 1.1666949164886008e-06 0.022910000000000003 -6.4105542819305688e-06 0.022920000000000003 -3.3582588861112131e-06 0.022930000000000002 -9.5678177544981658e-07 0.022940000000000002 -6.0532430283589536e-06 0.022950000000000002 -1.5783062608568961e-06 0.022960000000000001 3.1680276528508365e-06 0.022970000000000001 -8.149727658839343e-06 0.02298 1.4240461961128065e-06 0.022990000000000003 -1.6258492421888721e-06 0.023000000000000003 5.296632038654287e-06 0.023010000000000003 -6.931216828880646e-06 0.023020000000000002 -4.482689294260786e-06 0.023030000000000002 -5.541805377123541e-06 0.023040000000000001 5.241746912992106e-06 0.023050000000000001 4.1439237676825008e-06 0.023060000000000001 2.9012604446095645e-06 0.02307 6.6026191982479652e-06 0.023080000000000003 7.8768879117201506e-06 0.023090000000000003 9.7714573952359394e-06 0.023100000000000002 2.1216526746772651e-06 0.023110000000000002 5.244961812199376e-06 0.023120000000000002 -5.2397108182166702e-06 0.023130000000000001 9.5251130289700229e-07 0.023140000000000001 -4.3002882766229008e-06 0.02315 -1.6332117783621005e-06 0.023160000000000004 4.6967661945321321e-07 0.023170000000000003 7.0334203564734527e-07 0.023180000000000003 -2.1566276688586087e-06 0.023190000000000002 6.0330215156388103e-07 0.023200000000000002 -1.5154718012814244e-06 0.023210000000000001 5.98395068715379e-06 0.023220000000000001 -2.6046583331727974e-06 0.023230000000000001 -1.3875004260313102e-05 0.02324 7.9903858244458968e-06 0.023250000000000003 -3.4400073891903423e-07 0.023260000000000003 5.4227206587718875e-06 0.023270000000000002 -8.9707303782909224e-07 0.023280000000000002 7.4062157650733537e-06 0.023290000000000002 3.7368491764352843e-06 0.023300000000000001 5.2678915182865097e-07 0.023310000000000001 3.8292447257090352e-06 0.02332 2.5684728722629863e-06 0.023330000000000004 2.4160140344163867e-06 0.023340000000000003 -6.2027527465575387e-06 0.023350000000000003 -8.774937074652506e-06 0.023360000000000002 -7.2310513638404057e-06 0.023370000000000002 -1.6779006792794314e-06 0.023380000000000001 7.831933697602077e-06 0.023390000000000001 -3.481589133527365e-06 0.023400000000000001 2.0270476547498178e-06 0.02341 -5.6484254593133288e-07 0.023420000000000003 -1.2243653998235088e-05 0.023430000000000003 -1.4196481815611524e-06 0.023440000000000003 7.6362610168237176e-06 0.023450000000000002 2.3336807462626221e-07 0.023460000000000002 -3.7777089747481783e-06 0.023470000000000001 4.873719518761311e-06 0.023480000000000001 -7.7278266264986785e-06 0.02349 2.8922153450248173e-06 0.023500000000000004 -3.5763935175493871e-06 0.023510000000000003 2.659534102263575e-06 0.023520000000000003 -2.6087063172433717e-06 0.023530000000000002 8.4917329266335423e-06 0.023540000000000002 7.9601573202095159e-06 0.023550000000000001 -1.8700225640465383e-06 0.023560000000000001 2.5655622059126179e-06 0.023570000000000001 -6.6466215486122954e-06 0.02358 -3.4455270284715882e-06 0.023590000000000003 2.9974030454133917e-06 0.023600000000000003 5.6060700164011049e-06 0.023610000000000003 3.1112073536019692e-06 0.023620000000000002 2.3205607232984037e-07 0.023630000000000002 5.2347333385127112e-06 0.023640000000000001 6.4911383411703388e-06 0.023650000000000001 9.6497326246325065e-07 0.02366 5.4799554445770655e-06 0.023670000000000004 -5.3976576059021056e-06 0.023680000000000003 6.5269390243952013e-06 0.023690000000000003 -8.6110481754492808e-06 0.023700000000000002 -1.565103382770612e-06 0.023710000000000002 6.4512853713207925e-06 0.023720000000000001 8.7373994612735578e-06 0.023730000000000001 -4.0554186440235251e-06 0.023740000000000001 3.8265012667632782e-06 0.02375 6.2324269046971903e-07 0.023760000000000003 4.26214273094222e-06 0.023770000000000003 -6.5314967126260056e-06 0.023780000000000003 3.3781648634193696e-06 0.023790000000000002 -8.0121158572353237e-06 0.023800000000000002 3.3199588606726134e-06 0.023810000000000001 4.3345772295040348e-06 0.023820000000000001 -2.9716157885205561e-06 0.02383 1.6445049384388655e-07 0.023840000000000004 1.1006074922713847e-05 0.023850000000000003 -5.9329129991961752e-06 0.023860000000000003 -6.5047952057926791e-06 0.023870000000000002 -1.0348233411896007e-05 0.023880000000000002 -2.8361569429045265e-06 0.023890000000000002 -9.094100963656327e-07 0.023900000000000001 6.277535668329073e-06 0.023910000000000001 -3.7045578118085345e-06 0.02392 -1.5102247485028476e-06 0.023930000000000003 -1.9657946476175417e-06 0.023940000000000003 -6.3376454844325955e-07 0.023950000000000003 -5.7883779909623772e-06 0.023960000000000002 -8.7154005017970746e-06 0.023970000000000002 8.1356599740485712e-07 0.023980000000000001 3.1013832739537077e-06 0.023990000000000001 2.8789000928295985e-06 0.024 -7.9188445603838382e-06)
Vcornoise1 cornoise1 0 PWL(0 9.6421558723006355e-06 1.0000000000000001e-05 -3.129535613196422e-06 2.0000000000000002e-05 6.7876124645832088e-06 3.0000000000000004e-05 -3.7490441860168356e-06 4.0000000000000003e-05 2.5037895301849293e-06 5.0000000000000002e-05 2.0431543007279463e-07 6.0000000000000008e-05 -3.0350143061540666e-06 7.0000000000000007e-05 -3.1423513136666582e-06 8.0000000000000007e-05 2.5868349995071933e-07 9.0000000000000006e-05 4.8322917553269286e-06 0.0001 6.1807344230924426e-06 0.00011 -1.4057766069528164e-06 0.00012000000000000002 -2.4174348976990747e-06 0.00013000000000000002 4.9220221742100105e-08 0.00014000000000000001 2.7495885654472403e-07 0.00015000000000000001 -9.9751784353961671e-06 0.00016000000000000001 3.8160180446605826e-06 0.00017000000000000001 4.1970747329109756e-08 0.00018000000000000001 6.9809471937215509e-06 0.00019000000000000001 -1.1211707597669149e-06 0.00020000000000000001 7.2062359409373454e-07 0.00021000000000000001 2.9545053403663487e-06 0.00022000000000000001 5.9998062264069412e-07 0.00023000000000000001 2.1614434414315761e-06 0.00024000000000000003 8.0091702754777615e-06 0.00025000000000000001 1.2097372231338827e-05 0.00026000000000000003 2.7579406078923428e-06 0.00027 6.402507390645761e-06 0.00028000000000000003 3.4339801767913695e-06 0.00029 5.6877510952298544e-06 0.00030000000000000003 -3.8977492743622004e-06 0.00031 1.21081561654394e-06 0.00032000000000000003 5.7813617922420558e-08 0.00033000000000000005 -1.1492302882705162e-06 0.00034000000000000002 6.3532789828999852e-06 0.00035000000000000005 -2.0265443401844125e-06 0.00036000000000000002 2.6919576448761403e-06 0.00037000000000000005 -6.0422232020014101e-07 0.00038000000000000002 6.2342712032495592e-06 0.00039000000000000005 3.655792608805362e-06 0.00040000000000000002 -8.3028303128975858e-06 0.00041000000000000005 6.480541161657e-06 0.00042000000000000002 4.9833015134875811e-06 0.00043000000000000004 1.2629972358411806e-05 0.00044000000000000002 1.6102907860126726e-06 0.00045000000000000004 5.8926176934576983e-06 0.00046000000000000001 -2.012512736984175e-06 0.00047000000000000004 -1.1996753114019508e-05 0.00048000000000000007 -1.960600280932732e-06 0.00049000000000000009 -2.4512067162974497e-07 0.00050000000000000001 1.8705272722580608e-06 0.00051000000000000004 6.7372391689986309e-06 0.00052000000000000006 -2.910309238962726e-06 0.00053000000000000009 8.8631138620069097e-06 0.00054000000000000001 -4.476533568091483e-06 0.00055000000000000003 -7.3174412451010655e-06 0.00056000000000000006 -3.4961028208583624e-06 0.00057000000000000009 -5.563718981550296e-06 0.00058 -5.034514158180214e-07 0.00059000000000000003 -6.1250386204193649e-06 0.00060000000000000006 7.2679333073948371e-07 0.00061000000000000008 -3.2377476768541464e-06 0.00062 -6.5221659022417195e-07 0.00063000000000000003 -6.206591226028081e-06 0.00064000000000000005 6.3897961851863026e-06 0.00065000000000000008 1.1974104370693864e-06 0.0006600000000000001 -6.9900357852238917e-06 0.00067000000000000002 -1.4475929049359678e-06 0.00068000000000000005 -5.2129964551903201e-06 0.00069000000000000008 6.474412053683973e-06 0.0007000000000000001 6.5693351184478937e-06 0.00071000000000000002 1.0277723112039301e-06 0.00072000000000000005 -2.9651140658513044e-06 0.00073000000000000007 3.0132564047339624e-06 0.0007400000000000001 -8.7078326314247635e-06 0.00075000000000000002 -1.5905902920920585e-06 0.00076000000000000004 2.6116444362463671e-06 0.00077000000000000007 9.1348632855463821e-07 0.00078000000000000009 -4.6364488598091753e-06 0.00079000000000000001 2.6822448115639167e-07 0.00080000000000000004 -4.8421770512814528e-06 0.00081000000000000006 -3.0376800854456743e-07 0.00082000000000000009 -9.3734988391828961e-07 0.00083000000000000012 -4.522592146054464e-06 0.00084000000000000003 5.6119847803686508e-06 0.00085000000000000006 9.3876287588548757e-06 0.00086000000000000009 -5.4070674587816494e-06 0.00087000000000000011 2.843390403411947e-06 0.00088000000000000003 8.1681085243375543e-06 0.00089000000000000006 4.3624376539295899e-06 0.00090000000000000008 -2.2143457892749351e-06 0.00091000000000000011 1.4113277070395448e-06 0.00092000000000000003 -6.5178330615502551e-07 0.00093000000000000005 1.3303478306070159e-06 0.00094000000000000008 4.5805102859540729e-06 0.00095000000000000011 -4.2614331799609916e-06 0.00096000000000000013 -7.9652424168917556e-06 0.00097000000000000005 -5.4918173786803989e-07 0.00098000000000000019 -3.3327729891278311e-06 0.00098999999999999999 3.6313625733522358e-06 0.001 5.8911506187091129e-06 0.00101 -1.1479213489038644e-06 0.0010200000000000001 -1.5555116793556948e-06 0.0010300000000000001 -3.3587419250634059e-07 0.0010400000000000001 -5.4405930444963094e-06 0.0010500000000000002 -3.0765534794232198e-06 0.0010600000000000002 2.1728953457568772e-06 0.00107 3.8266987830793878e-07 0.00108 -5.4707344623081445e-06 0.00109 1.3570371035131594e-06 0.0011000000000000001 -8.4778902637809692e-06 0.0011100000000000001 3.2722887561281424e-06 0.0011200000000000001 7.2021831881373725e-06 0.0011300000000000001 2.7659892552123431e-06 0.0011400000000000002 5.6118141551243385e-06 0.0011500000000000002 3.1431383911592223e-06 0.00116 2.2543731727993277e-06 0.00117 -3.496651732355984e-06 0.0011800000000000001 -7.3007634569685212e-06 0.0011900000000000001 3.4241298845966394e-06 0.0012000000000000001 -2.8203344826975819e-06 0.0012100000000000001 3.5238727618139466e-06 0.0012200000000000002 -2.9336197248783045e-07 0.0012300000000000002 -8.6620713842989232e-07 0.00124 2.868760451387627e-06 0.00125 -3.5598623425861129e-06 0.0012600000000000001 -2.9293567519258644e-06 0.0012700000000000001 -2.9488762261478562e-06 0.0012800000000000001 9.6523091884259028e-07 0.0012900000000000001 -4.4092436646264089e-06 0.0013000000000000002 -4.6175748052932009e-06 0.0013100000000000002 7.5770471989861691e-06 0.0013200000000000002 3.2841665536256985e-06 0.00133 -3.1957305276325791e-06 0.00134 6.2019662878694322e-06 0.0013500000000000001 9.8690201848708933e-06 0.0013600000000000001 6.1764544606527503e-06 0.0013700000000000001 -3.1003080760671916e-06 0.0013800000000000002 -4.7920901545005481e-06 0.0013900000000000002 2.294202630377588e-07 0.0014000000000000002 -1.6502296954527935e-06 0.00141 -1.4145223065398451e-07 0.00142 -3.3654329511019186e-06 0.0014300000000000001 5.3051887455916171e-07 0.0014400000000000001 7.6207018516069429e-06 0.0014500000000000001 -3.3930969173321351e-06 0.0014600000000000001 1.9455357354267208e-06 0.0014700000000000002 5.1622554040882821e-06 0.0014800000000000002 -6.8478608354791365e-06 0.0014900000000000002 -4.7233853685558703e-06 0.0015 2.3902592122960305e-06 0.0015100000000000001 6.7252111075090576e-06 0.0015200000000000001 3.7029214476791043e-08 0.0015300000000000001 -3.1008663090398782e-06 0.0015400000000000001 -1.0526408245347157e-05 0.0015500000000000002 -2.5522867583404498e-06 0.0015600000000000002 -3.9558844534257229e-06 0.0015700000000000002 4.8177197771286759e-06 0.00158 -5.8824672863313459e-06 0.0015900000000000001 -1.2171186491546144e-06 0.0016000000000000001 -1.2961619232896613e-07 0.0016100000000000001 3.9293984397301669e-06 0.0016200000000000001 2.361064873145439e-06 0.0016300000000000002 -3.658959230128581e-06 0.0016400000000000002 6.6185122287612869e-07 0.0016500000000000002 3.1343358300888448e-06 0.0016600000000000002 1.7218361185718643e-06 0.00167 2.9908069721408176e-06 0.0016800000000000001 3.5059573032013056e-06 0.0016900000000000001 -4.1356234425492644e-06 0.0017000000000000001 -2.617715988693814e-07 0.0017100000000000001 2.6053432248894955e-06 0.0017200000000000002 -2.8058043122289685e-06 0.0017300000000000002 3.6865621233350048e-06 0.0017400000000000002 1.2332704008533256e-05 0.00175 -1.3009480719620362e-06 0.0017600000000000001 4.6577994577025509e-06 0.0017700000000000001 2.3279593067737442e-06 0.0017800000000000001 4.7713009471354352e-06 0.0017900000000000001 5.723209717202114e-06 0.0018000000000000002 1.1177490577441363e-05 0.0018100000000000002 3.2037219223372848e-07 0.0018200000000000002 1.0135043883919456e-06 0.0018300000000000002 9.3583810297139562e-06 0.0018400000000000001 -5.3882921727357893e-06 0.0018500000000000001 -8.5259941482958313e-09 0.0018600000000000001 -3.0675760800041298e-06 0.0018700000000000001 4.547799496619922e-06 0.0018800000000000002 -4.6129422985058441e-06 0.0018900000000000002 2.254354960763023e-06 0.0019000000000000002 -1.158732863171986e-05 0.0019100000000000002 5.7509512883096642e-06 0.0019200000000000003 1.0315533293246887e-06 0.0019300000000000001 1.6692762077873375e-06 0.0019400000000000001 -1.1911912697083655e-05 0.0019500000000000001 3.521168163527558e-06 0.0019600000000000004 4.5775555749121215e-06 0.00197 7.834565877346224e-06 0.00198 -7.2738100059124047e-06 0.00199 2.754935621291791e-06 0.002 3.9120030821937308e-06 0.0020100000000000001 -2.8627062493027836e-06 0.0020200000000000001 3.9421191843649391e-06 0.0020300000000000001 -2.9363886599391355e-06 0.0020400000000000001 1.0289653075097952e-05 0.0020500000000000002 8.3200281415555701e-06 0.0020600000000000002 -1.5219439161766323e-06 0.0020700000000000002 -6.0981551592057113e-06 0.0020800000000000003 1.9472654429447511e-06 0.0020900000000000003 -1.1073119285248712e-06 0.0021000000000000003 -2.448222959032635e-06 0.0021100000000000003 -2.3377336773927994e-06 0.0021200000000000004 7.538946326925007e-06 0.0021300000000000004 5.0517932618377466e-06 0.00214 9.4636008772909143e-06 0.00215 4.5852395871658773e-06 0.00216 2.7368146256188764e-06 0.0021700000000000001 -3.8750327167921535e-06 0.0021800000000000001 6.0988465188653495e-07 0.0021900000000000001 6.4716353411020668e-06 0.0022000000000000001 2.1007242182680212e-06 0.0022100000000000002 3.1434076583535047e-07 0.0022200000000000002 -1.878248351749708e-06 0.0022300000000000002 1.2440826031653965e-06 0.0022400000000000002 -5.3061294366876596e-07 0.0022500000000000003 -1.9906595473968097e-06 0.0022600000000000003 7.1379419121131732e-06 0.0022700000000000003 1.2514142705016941e-06 0.0022800000000000003 -5.539832397990674e-06 0.0022900000000000004 6.0269492833905356e-06 0.0023000000000000004 1.0985067756849166e-06 0.00231 4.4327554518225728e-06 0.00232 -8.3468078722618052e-06 0.00233 4.9457595297545185e-06 0.0023400000000000001 2.3242493404888057e-06 0.0023500000000000001 8.262058732724824e-07 0.0023600000000000001 4.7205292188759293e-06 0.0023700000000000001 4.6681168219014431e-06 0.0023800000000000002 8.7134372255572688e-08 0.0023900000000000002 1.826730407831689e-06 0.0024000000000000002 8.3452143248481019e-06 0.0024100000000000002 3.8229382043155142e-06 0.0024200000000000003 1.1685305521271647e-05 0.0024300000000000003 -1.9280628344161196e-06 0.0024400000000000003 5.4077529907959756e-06 0.0024500000000000004 -3.5984846847420257e-06 0.0024600000000000004 7.4205576156927635e-06 0.0024700000000000004 -3.5748293880071807e-06 0.00248 -2.5519631360823938e-06 0.00249 -8.0090195629504221e-06 0.0025000000000000001 -8.4347068886331306e-07 0.0025100000000000001 -1.4207659849816833e-06 0.0025200000000000001 3.8034213389857947e-06 0.0025300000000000001 5.1281798779565603e-06 0.0025400000000000002 3.5742113346841513e-06 0.0025500000000000002 2.7643808756945962e-06 0.0025600000000000002 -6.1144128024644188e-06 0.0025700000000000002 -9.2725816329552272e-06 0.0025800000000000003 6.2337754516302682e-06 0.0025900000000000003 4.0787700337890779e-06 0.0026000000000000003 -2.5700948347110556e-06 0.0026100000000000003 -1.6218024338596801e-05 0.0026200000000000004 -3.852960681552391e-06 0.0026300000000000004 1.7060679376531831e-07 0.0026400000000000004 -4.856335109410228e-06 0.00265 -4.7075419814434649e-06 0.00266 -4.3382432013102814e-06 0.0026700000000000001 -1.4118111583232646e-06 0.0026800000000000001 1.0270858730344693e-09 0.0026900000000000001 -2.9640255521657358e-06 0.0027000000000000001 -6.3778937775080454e-06 0.0027100000000000002 3.7650797981265348e-06 0.0027200000000000002 8.1173924787565224e-07 0.0027300000000000002 8.1417154175903022e-07 0.0027400000000000002 -8.0206582341742076e-06 0.0027500000000000003 -9.9528733692481136e-07 0.0027600000000000003 -2.7652307087469279e-06 0.0027700000000000003 4.3620643688397947e-06 0.0027800000000000004 -3.6980118534257244e-06 0.0027900000000000004 -2.1832890278883047e-06 0.0028000000000000004 5.1947621335147093e-06 0.0028100000000000004 -7.6749181096835559e-06 0.00282 2.8292669447713892e-06 0.0028300000000000001 -2.822013460364028e-06 0.0028400000000000001 1.7619029294393847e-06 0.0028500000000000001 -1.8955084578573095e-06 0.0028600000000000001 -2.0710018305820643e-06 0.0028700000000000002 -1.0202495621471403e-05 0.0028800000000000002 -1.0848786812862144e-05 0.0028900000000000002 -2.9434020480928681e-06 0.0029000000000000002 3.1009588565213639e-06 0.0029100000000000003 -2.8884917575579826e-06 0.0029200000000000003 7.7495197203849603e-08 0.0029300000000000003 1.9322906034658855e-06 0.0029400000000000003 1.4559953074712634e-05 0.0029500000000000004 -4.0090238777304069e-06 0.0029600000000000004 -1.0237522515438959e-06 0.0029700000000000004 4.4390219514910071e-06 0.0029800000000000004 -8.3569763413208326e-06 0.00299 -2.8236260751131227e-06 0.0030000000000000001 -5.6770433868999738e-06 0.0030100000000000001 -1.5254550754294951e-06 0.0030200000000000001 -2.3173841216145477e-06 0.0030300000000000001 -1.0174810398114345e-05 0.0030400000000000002 -2.8535587361864784e-06 0.0030500000000000002 -8.1562791506410821e-06 0.0030600000000000002 -5.9826502270747865e-06 0.0030700000000000002 -2.0922960212574088e-06 0.0030800000000000003 6.7071342776705929e-06 0.0030900000000000003 4.8001028218569246e-06 0.0031000000000000003 -3.0002925552646174e-06 0.0031100000000000004 1.4675195221145892e-06 0.0031200000000000004 -4.7268931217631762e-06 0.0031300000000000004 -1.1323367525473216e-06 0.0031400000000000004 -6.3929901254841167e-06 0.0031500000000000005 -1.1708443938241437e-05 0.00316 -4.5567430908137159e-06 0.0031700000000000001 -2.6151945154760267e-06 0.0031800000000000001 -4.5436603063243306e-06 0.0031900000000000001 -2.6274496502115125e-06 0.0032000000000000002 7.4771408644034883e-06 0.0032100000000000002 -9.8501241117270116e-06 0.0032200000000000002 -4.1714323483857215e-06 0.0032300000000000002 4.4141688076076479e-06 0.0032400000000000003 8.173439522302918e-06 0.0032500000000000003 -4.1444112680287122e-06 0.0032600000000000003 3.1891050241613226e-06 0.0032700000000000003 8.7162846437270685e-07 0.0032800000000000004 1.8999448646094545e-06 0.0032900000000000004 -2.1700296813792183e-06 0.0033000000000000004 4.2369180800097864e-07 0.0033100000000000004 -1.1625686766949742e-06 0.0033200000000000005 -4.3291680420752941e-07 0.0033300000000000001 -2.4197236980969117e-06 0.0033400000000000001 2.3162245964420151e-06 0.0033500000000000001 -9.4706120539587109e-06 0.0033600000000000001 3.2440816084630659e-06 0.0033700000000000002 -2.0125335996840293e-06 0.0033800000000000002 -2.3751877208747839e-06 0.0033900000000000002 4.045149169416567e-06 0.0034000000000000002 3.382855662146846e-06 0.0034100000000000003 -4.0312076223825764e-06 0.0034200000000000003 6.858591667182045e-07 0.0034300000000000003 1.6136170191576037e-06 0.0034400000000000003 7.7757729906584671e-06 0.0034500000000000004 2.6007286414929151e-06 0.0034600000000000004 9.1607066578765988e-06 0.0034700000000000004 -4.5791476857821866e-06 0.0034800000000000005 -2.3244545214885157e-06 0.0034900000000000005 -5.3372256090861851e-06 0.0035000000000000001 -3.6652254956241192e-06 0.0035100000000000001 -3.2374888694814155e-06 0.0035200000000000001 -2.5720658914196967e-06 0.0035300000000000002 -1.5598210173167829e-06 0.0035400000000000002 1.5174051629413858e-06 0.0035500000000000002 4.9544444805402877e-07 0.0035600000000000002 -2.202175609193507e-06 0.0035700000000000003 7.2050417612783882e-06 0.0035800000000000003 -7.7987226130620716e-06 0.0035900000000000003 6.374292806934753e-06 0.0036000000000000003 -7.9620314658669156e-06 0.0036100000000000004 9.503102193470161e-07 0.0036200000000000004 2.0096443160215303e-06 0.0036300000000000004 7.9262545549133674e-06 0.0036400000000000004 -1.4264562062716284e-06 0.0036500000000000005 5.5190383871622022e-06 0.0036600000000000005 -1.9781825664573402e-06 0.0036700000000000001 -5.0432648822781613e-06 0.0036800000000000001 -1.3998293736075348e-05 0.0036900000000000001 2.2959697734068952e-06 0.0037000000000000002 -2.8085463544384917e-06 0.0037100000000000002 -8.9381076070495798e-07 0.0037200000000000002 -2.7251424377238232e-06 0.0037300000000000002 9.3769828641622532e-06 0.0037400000000000003 -4.5158408570163574e-06 0.0037500000000000003 -3.2122147090350221e-06 0.0037600000000000003 3.5824288572863248e-06 0.0037700000000000003 3.7259904476127455e-06 0.0037800000000000004 1.1362955570235669e-08 0.0037900000000000004 -6.1416666638035394e-06 0.0038000000000000004 -3.052814562444447e-06 0.0038100000000000005 -1.1530428421461188e-05 0.0038200000000000005 7.0703753233091277e-06 0.0038300000000000005 -1.610752961697894e-06 0.0038400000000000005 -6.5153152391163696e-06 0.0038500000000000001 2.7007581153265573e-06 0.0038600000000000001 2.1917489772741463e-06 0.0038700000000000002 -1.8871961461045981e-06 0.0038800000000000002 -1.4642660820055433e-06 0.0038900000000000002 2.7614944314313697e-06 0.0039000000000000003 7.4420288364289325e-06 0.0039100000000000003 8.2737568173414769e-07 0.0039200000000000007 -2.7476753132055424e-06 0.0039300000000000003 2.6054279345402939e-06 0.0039399999999999999 -6.3315482090656808e-06 0.0039500000000000004 2.8799152742033799e-07 0.00396 -1.5394708929120731e-06 0.0039700000000000004 2.0750540790172437e-06 0.00398 5.5241717238035772e-06 0.0039900000000000005 -7.8040201800678822e-07 0.0040000000000000001 3.6633118407436046e-06 0.0040100000000000005 -6.2230272117875205e-06 0.0040200000000000001 8.8207125363238688e-06 0.0040300000000000006 6.6411377089208466e-06 0.0040400000000000002 4.3454760797198072e-06 0.0040500000000000006 4.5169664551114942e-06 0.0040600000000000002 -1.9877877187676973e-06 0.0040700000000000007 -2.5765194370855905e-06 0.0040800000000000003 -4.0442430313200194e-07 0.0040900000000000008 2.4188933426119373e-06 0.0041000000000000003 4.4942584366685494e-06 0.0041099999999999999 -6.2980960408069835e-06 0.0041200000000000004 1.9089698214399878e-06 0.00413 7.3444858104200082e-08 0.0041400000000000005 6.4297294659915843e-07 0.00415 -2.4028000004974698e-06 0.0041600000000000005 3.6846743839447983e-06 0.0041700000000000001 -5.3258649976247504e-06 0.0041800000000000006 2.8025688245006389e-06 0.0041900000000000001 -2.3383389237814857e-06 0.0042000000000000006 3.5203965514494811e-06 0.0042100000000000002 -2.5999993808747233e-06 0.0042200000000000007 2.5737414126015618e-06 0.0042300000000000003 4.2038740167647647e-07 0.0042400000000000007 -7.4427726588970803e-08 0.0042500000000000003 7.1324684470865561e-06 0.0042600000000000008 3.3174204113293783e-06 0.0042700000000000004 9.728549440107424e-06 0.00428 -1.108369397980715e-05 0.0042900000000000004 -2.516593384103559e-06 0.0043 7.7883484677784777e-06 0.0043100000000000005 3.9645366349006777e-06 0.0043200000000000001 -2.796337252389134e-06 0.0043300000000000005 -1.8152388831782652e-06 0.0043400000000000001 -2.9487066292221523e-07 0.0043500000000000006 -4.4623896735379192e-06 0.0043600000000000002 4.2216689472721676e-06 0.0043700000000000006 -6.6391846819480413e-06 0.0043800000000000002 4.7360106160345704e-06 0.0043900000000000007 -3.5666772887186781e-06 0.0044000000000000003 -8.9828466591335523e-06 0.0044100000000000007 7.6388527047591603e-06 0.0044200000000000003 3.5597169885087163e-06 0.0044300000000000008 -7.4786156139977909e-06 0.0044400000000000004 -1.7012939026867037e-07 0.00445 1.9077101604170726e-06 0.0044600000000000004 -4.5792486708810804e-07 0.00447 6.1042440433327202e-06 0.0044800000000000005 2.6673909639423669e-06 0.0044900000000000001 -2.1498250270786999e-06 0.0045000000000000005 -4.3977365298986047e-06 0.0045100000000000001 -3.8086102481951574e-06 0.0045200000000000006 2.2648986233919894e-06 0.0045300000000000002 -3.6140038603031472e-06 0.0045400000000000006 -2.2947989354324057e-06 0.0045500000000000002 -1.7048263866023925e-07 0.0045600000000000007 -1.4371876739639712e-06 0.0045700000000000003 4.9970616662598067e-06 0.0045800000000000007 3.8088258544012364e-06 0.0045900000000000003 2.9896575685498491e-06 0.0046000000000000008 4.5787312481057603e-06 0.0046100000000000004 -5.0248330470866861e-06 0.00462 -4.8742152335841386e-07 0.0046300000000000004 -4.2447127233961453e-06 0.00464 1.0359129598655395e-07 0.0046500000000000005 -1.0272257746658765e-06 0.0046600000000000001 -6.2106510684399672e-06 0.0046700000000000005 3.9644042967787553e-06 0.0046800000000000001 -8.1482359398281799e-06 0.0046900000000000006 -3.4218562635353046e-06 0.0047000000000000002 -2.2122257339572961e-06 0.0047100000000000006 5.0081850625934459e-07 0.0047200000000000002 -9.1840755739813386e-06 0.0047300000000000007 -4.2589238894225093e-07 0.0047400000000000003 4.1224824388419922e-06 0.0047500000000000007 1.6768811116942837e-06 0.0047600000000000003 2.118369647319561e-06 0.0047700000000000008 -7.9792053722770638e-06 0.0047800000000000004 1.7139081352791128e-06 0.00479 -1.4323736368358173e-06 0.0048000000000000004 -8.3837570708585935e-07 0.00481 -2.1829330752227965e-06 0.0048200000000000005 5.6075191315754133e-06 0.0048300000000000001 1.0527960199042032e-06 0.0048400000000000006 2.0781894722861605e-06 0.0048500000000000001 6.6554894169694561e-06 0.0048600000000000006 -9.7036991144965035e-06 0.0048700000000000002 3.0113083784886914e-06 0.0048800000000000007 -3.2933226198081032e-06 0.0048900000000000002 9.1943452217922611e-06 0.0049000000000000007 1.0394697901517448e-05 0.0049100000000000003 -4.7767616307477968e-06 0.0049200000000000008 -8.2981682054724294e-06 0.0049300000000000004 -2.2142453589611528e-06 0.0049400000000000008 7.9472759126388839e-06 0.0049500000000000004 4.7831516357276439e-06 0.00496 -2.6457195866578338e-06 0.0049700000000000005 6.1697065207818998e-06 0.0049800000000000001 6.6548813387085874e-06 0.0049900000000000005 5.1120446547035506e-06 0.0050000000000000001 -5.6087401466491753e-06 0.0050100000000000006 -3.5127428168977018e-06 0.0050200000000000002 7.719046723295243e-06 0.0050300000000000006 -1.0123387632473577e-06 0.0050400000000000002 -6.9250546454316536e-06 0.0050500000000000007 -2.5661076817421327e-06 0.0050600000000000003 6.7226410555817678e-06 0.0050700000000000007 9.2630924134372659e-07 0.0050800000000000003 7.7868208133624801e-08 0.0050900000000000008 -2.4629145102027065e-06 0.0051000000000000004 -2.4988479830052421e-06 0.0051100000000000008 1.2423486513050222e-06 0.0051200000000000004 1.6157493718964748e-06 0.00513 5.5895737762186865e-07 0.0051400000000000005 1.5110938840572608e-06 0.0051500000000000001 -6.2570538361750322e-06 0.0051600000000000005 -1.2818608851914547e-06 0.0051700000000000001 -3.8136630393329664e-06 0.0051800000000000006 -2.8133978083141596e-06 0.0051900000000000002 7.5166799677229378e-06 0.0052000000000000006 -3.570122360198842e-06 0.0052100000000000002 5.7286022882777772e-06 0.0052200000000000007 -2.6541858305074019e-06 0.0052300000000000003 -4.0261138965090133e-06 0.0052400000000000007 -2.7738081158077311e-07 0.0052500000000000003 3.4301453642561883e-06 0.0052600000000000008 -9.1448366990266738e-07 0.0052700000000000004 -1.6262400854235968e-06 0.0052800000000000008 -7.3646243879070887e-06 0.0052900000000000004 -9.8706850400249639e-06 0.0053 -2.2407634476551697e-06 0.0053100000000000005 -3.9026423007979574e-07 0.0053200000000000001 3.5326878704561119e-06 0.0053300000000000005 -3.8744633587341982e-06 0.0053400000000000001 4.8470993394846841e-06 0.0053500000000000006 -2.4238152027391774e-07 0.0053600000000000002 6.9568104311713059e-06 0.0053700000000000006 4.3898908709831912e-06 0.0053800000000000002 -4.2260623061115792e-07 0.0053900000000000007 4.2932691985280026e-06 0.0054000000000000003 -3.3670750289328869e-06 0.0054100000000000007 7.1052682417842634e-06 0.0054200000000000003 3.3952130176458239e-06 0.0054300000000000008 -7.2102515842809582e-06 0.0054400000000000004 9.209062520703361e-06 0.0054500000000000009 7.1084452667737359e-06 0.0054600000000000004 1.7253465998863306e-06 0.00547 -2.9297325770454649e-06 0.0054800000000000005 3.3784818700142107e-07 0.0054900000000000001 -7.8922521888077548e-06 0.0055000000000000005 -3.83633796357059e-06 0.0055100000000000001 3.1527349801646202e-06 0.0055200000000000006 -6.7477575241723488e-07 0.0055300000000000002 -3.1487990218762119e-06 0.0055400000000000007 -1.080229258348418e-06 0.0055500000000000002 1.5858828821172754e-06 0.0055600000000000007 -2.378796092038256e-06 0.0055700000000000003 -5.7673659655809157e-06 0.0055800000000000008 4.4263439850110742e-06 0.0055900000000000004 1.2200849394993363e-05 0.0056000000000000008 3.8938170616387609e-06 0.0056100000000000004 1.5533630567061585e-08 0.0056200000000000009 4.4985785989054974e-07 0.0056300000000000005 -1.1338096044449231e-05 0.00564 3.4854373572730961e-06 0.0056500000000000005 -4.5297216623661986e-06 0.0056600000000000001 1.8000403432318291e-06 0.0056700000000000006 -1.210739190867761e-05 0.0056800000000000002 -2.778748915248723e-06 0.0056900000000000006 6.2089238567014416e-06 0.0057000000000000002 2.4511576210473541e-06 0.0057100000000000007 -6.909480353691598e-06 0.0057200000000000003 4.8170833981932261e-06 0.0057300000000000007 2.835351379817407e-06 0.0057400000000000003 -3.7709041909962293e-06 0.0057500000000000008 2.2981818469956806e-07 0.0057600000000000004 -7.0267388387949612e-06 0.0057700000000000008 2.7707723296347628e-06 0.0057800000000000004 -1.9472698934410131e-06 0.0057900000000000009 3.5361824317737991e-07 0.0058000000000000005 2.6150199383192387e-06 0.0058100000000000001 1.8766734682132711e-06 0.0058200000000000005 -5.586225797852262e-06 0.0058300000000000001 -2.9860902615545633e-06 0.0058400000000000006 1.3907550823789445e-06 0.0058500000000000002 -2.7167617646714353e-08 0.0058600000000000006 -7.7787070630092829e-07 0.0058700000000000002 -2.9155261747283195e-07 0.0058800000000000007 -5.5549637529565026e-06 0.0058900000000000003 2.3562453970132182e-06 0.0059000000000000007 1.4277861800821346e-06 0.0059100000000000003 5.370015302617648e-06 0.0059200000000000008 -3.528010475648111e-06 0.0059300000000000004 6.2074370484163131e-06 0.0059400000000000008 -5.3337595662447973e-06 0.0059500000000000004 4.5945167576087231e-06 0.0059600000000000009 8.8034533889636816e-06 0.0059700000000000005 -1.438408807690304e-06 0.0059800000000000001 -5.3685934507040575e-06 0.0059900000000000005 -1.7463011967177706e-06 0.0060000000000000001 8.2373172794215086e-06 0.0060100000000000006 -3.7605318391955369e-06 0.0060200000000000002 -5.0432913442512465e-06 0.0060300000000000006 2.2910518225694407e-06 0.0060400000000000002 7.2979746596595203e-07 0.0060500000000000007 -6.7362111262451634e-06 0.0060600000000000003 -8.1316987776929785e-06 0.0060700000000000007 3.8524535800687703e-06 0.0060800000000000003 7.8435969010830815e-06 0.0060900000000000008 2.7398790045255555e-07 0.0061000000000000004 2.2960562019168396e-06 0.0061100000000000008 3.4492813362299925e-07 0.0061200000000000004 -9.7635903265164375e-07 0.0061300000000000009 -3.6818150973081418e-06 0.0061400000000000005 -9.7766340571478597e-06 0.0061500000000000001 4.0258257825865841e-06 0.0061600000000000005 -5.0166194755218189e-06 0.0061700000000000001 -6.0283623428457164e-06 0.0061800000000000006 -8.3044948406154853e-06 0.0061900000000000002 9.989815348160737e-07 0.0062000000000000006 -9.591071016510505e-08 0.0062100000000000002 -2.0877284665851537e-06 0.0062200000000000007 -5.9854159329944117e-06 0.0062300000000000003 3.3854205520281802e-06 0.0062400000000000008 -7.8839744195997983e-06 0.0062500000000000003 -2.7584077635365319e-06 0.0062600000000000008 2.7138958180488554e-06 0.0062700000000000004 1.9623335985036966e-06 0.0062800000000000009 4.499380810349873e-06 0.0062900000000000005 4.1678402871868591e-06 0.0063000000000000009 3.9513434536065753e-06 0.0063100000000000005 -5.4354654136583382e-06 0.0063200000000000001 5.5129705098297391e-06 0.0063300000000000006 -3.7568761762315957e-06 0.0063400000000000001 -5.7260644142159197e-06 0.0063500000000000006 6.8633158366948002e-06 0.0063600000000000002 -3.1746559572704683e-06 0.0063700000000000007 5.7098756725064649e-07 0.0063800000000000003 -6.1906971126401523e-06 0.0063900000000000007 3.3734499053720243e-06 0.0064000000000000003 -1.1704619146575627e-06 0.0064100000000000008 -1.3025344743033741e-06 0.0064200000000000004 -4.7876234055994704e-06 0.0064300000000000008 2.4197497362997144e-06 0.0064400000000000004 -2.6584139511030845e-06 0.0064500000000000009 -6.5051941518504292e-06 0.0064600000000000005 -8.0010551580376388e-08 0.0064700000000000009 6.1910103443165345e-06 0.0064800000000000005 7.9067864845210315e-07 0.0064900000000000001 -1.4798591094247697e-06 0.0065000000000000006 6.3412358853006317e-07 0.0065100000000000002 -4.9338149724401892e-06 0.0065200000000000006 -1.4933768974386819e-06 0.0065300000000000002 -2.8373091500561339e-07 0.0065400000000000007 6.3775120255216709e-06 0.0065500000000000003 6.2376762980405312e-06 0.0065600000000000007 3.8859325509910142e-06 0.0065700000000000003 8.8361242949258072e-06 0.0065800000000000008 3.1416159631211601e-06 0.0065900000000000004 -3.3632997903739006e-06 0.0066000000000000008 8.5716856861731577e-06 0.0066100000000000004 7.5889443909456993e-06 0.0066200000000000009 -1.6558550249232852e-06 0.0066300000000000005 -1.0934502599392698e-06 0.0066400000000000009 7.4373275765320155e-06 0.0066500000000000005 5.7334734736071046e-07 0.0066600000000000001 -4.2408899450404956e-06 0.0066700000000000006 -6.8825372394980747e-06 0.0066800000000000002 -5.3831447149647472e-06 0.0066900000000000006 -4.3781078887475806e-06 0.0067000000000000002 2.9213273616543469e-06 0.0067100000000000007 1.2197955530711775e-06 0.0067200000000000003 -2.9222236652128326e-06 0.0067300000000000007 7.3783951452700756e-06 0.0067400000000000003 4.4607926702127328e-06 0.0067500000000000008 -2.9384384849731477e-07 0.0067600000000000004 -1.0562134276568742e-05 0.0067700000000000008 4.4387359709824653e-06 0.0067800000000000004 1.6577083786776627e-06 0.0067900000000000009 5.9533755101611327e-06 0.0068000000000000005 -5.1544445795496094e-06 0.0068100000000000009 3.2396494937849625e-06 0.0068200000000000005 -7.7850503812598609e-07 0.0068300000000000001 -5.4280971134302948e-07 0.0068400000000000006 5.5886226350525681e-07 0.0068500000000000002 4.7448913968777978e-06 0.0068600000000000006 -8.5819474916654803e-06 0.0068700000000000002 2.6954563970624255e-06 0.0068800000000000007 -8.3635641393407134e-06 0.0068900000000000003 7.4221742061149573e-06 0.0069000000000000008 3.9585540547070049e-06 0.0069100000000000003 -6.9429426110220785e-06 0.0069200000000000008 9.458277013238882e-06 0.0069300000000000004 6.0996398120297099e-07 0.0069400000000000009 -7.7825042133866032e-06 0.0069500000000000004 1.9628037151988379e-07 0.0069600000000000009 -2.5903504955856499e-06 0.0069700000000000005 -1.0324542475460497e-05 0.006980000000000001 -5.9001303370976018e-06 0.0069900000000000006 8.0637009921484067e-07 0.0070000000000000001 6.210675650943926e-06 0.0070100000000000006 -5.2673520801236113e-06 0.0070200000000000002 -3.7658624825988534e-06 0.0070300000000000007 -2.1948000931996939e-06 0.0070400000000000003 2.4198867773359948e-06 0.0070500000000000007 -2.1361755058432797e-06 0.0070600000000000003 -4.5319960027627986e-06 0.0070700000000000008 5.2985547369934751e-07 0.0070800000000000004 1.0407580783953659e-05 0.0070900000000000008 6.8157478337165704e-06 0.0071000000000000004 4.2940105550755352e-06 0.0071100000000000009 -2.6280639520635236e-06 0.0071200000000000005 -2.1777240511038374e-06 0.0071300000000000009 -6.7788243392588385e-06 0.0071400000000000005 1.8726871074498742e-06 0.007150000000000001 2.4707811216112251e-06 0.0071600000000000006 -1.3994870852084804e-06 0.0071700000000000002 -1.2186022221758488e-06 0.0071800000000000006 1.1777980387459458e-05 0.0071900000000000002 2.0607299452482786e-06 0.0072000000000000007 2.4795601188362853e-06 0.0072100000000000003 -8.7209574625683797e-07 0.0072200000000000007 1.9541612657924335e-06 0.0072300000000000003 -8.5551819972599956e-06 0.0072400000000000008 5.2423873214462695e-06 0.0072500000000000004 8.7509317803194729e-06 0.0072600000000000008 -7.8772511037859806e-06 0.0072700000000000004 5.0987725065150725e-06 0.0072800000000000009 3.9466127906188165e-06 0.0072900000000000005 -7.4923067058914745e-06 0.0073000000000000009 6.3603945898526639e-06 0.0073100000000000005 -6.2320190931279404e-06 0.007320000000000001 -2.1227775997500392e-06 0.0073300000000000006 -2.5984179822972973e-06 0.0073400000000000002 -2.3349496130555197e-07 0.0073500000000000006 9.7865691363692635e-07 0.0073600000000000002 -2.9196756823042037e-06 0.0073700000000000007 -6.794820172604529e-07 0.0073800000000000003 -2.5821141932631218e-06 0.0073900000000000007 2.4605569581596955e-06 0.0074000000000000003 5.4983207511539168e-06 0.0074100000000000008 -2.5559375142939995e-06 0.0074200000000000004 -3.9585619685407515e-06 0.0074300000000000008 3.3156259178476148e-07 0.0074400000000000004 -3.1838755445315618e-06 0.0074500000000000009 9.8061840943939113e-06 0.0074600000000000005 -2.9460648873783076e-06 0.0074700000000000009 -1.0091138051255832e-05 0.0074800000000000005 1.8872955555774175e-06 0.007490000000000001 -2.0413925683447926e-06 0.0075000000000000006 -4.25995028011475e-06 0.0075100000000000002 -5.1697835252246487e-07 0.0075200000000000006 8.2104751110330767e-07 0.0075300000000000002 -2.987890700727082e-06 0.0075400000000000007 -3.3737496988841868e-06 0.0075500000000000003 -5.862082575937603e-06 0.0075600000000000007 3.9705482031351178e-06 0.0075700000000000003 1.0984578698598307e-06 0.0075800000000000008 -3.102371309129373e-06 0.0075900000000000004 7.453530161280552e-07 0.0076000000000000009 3.7033396577192669e-06 0.0076100000000000004 3.0786820164017365e-06 0.0076200000000000009 -1.3452598216347071e-06 0.0076300000000000005 5.9993128740813391e-06 0.007640000000000001 -1.2360090024100797e-08 0.0076500000000000005 -5.8718959515765616e-06 0.007660000000000001 2.5317430880804485e-06 0.0076700000000000006 -1.2449478051919201e-06 0.0076800000000000011 7.3190701401323714e-06 0.0076900000000000007 5.8865433785177318e-06 0.0077000000000000002 -2.8679504601509859e-06 0.0077100000000000007 5.7915606059964723e-06 0.0077200000000000003 3.4406132895450305e-06 0.0077300000000000008 4.7395791699362963e-06 0.0077400000000000004 4.487127744818823e-06 0.0077500000000000008 -6.5722276795733868e-06 0.0077600000000000004 7.6138417180904637e-06 0.0077700000000000009 6.613728272453526e-06 0.0077800000000000005 3.7285398076105139e-06 0.0077900000000000009 3.7647577679645043e-06 0.0078000000000000005 2.5208850799028122e-06 0.007810000000000001 7.1478961182919954e-07 0.0078200000000000006 -9.0737291520298223e-07 0.0078300000000000002 -3.8704061832354814e-06 0.0078400000000000015 6.3736315031385796e-06 0.0078500000000000011 1.0339892576219631e-05 0.0078600000000000007 -3.8491941607433869e-06 0.0078700000000000003 -5.0462322751037788e-06 0.0078799999999999999 -1.7462214256324282e-07 0.0078900000000000012 2.6699856955941167e-06 0.0079000000000000008 8.0150285709104745e-06 0.0079100000000000004 5.1266380369614148e-08 0.00792 -3.5753486058483485e-07 0.0079300000000000013 2.3192108215933605e-06 0.0079400000000000009 3.7178931879452553e-06 0.0079500000000000005 -2.4375491374952468e-06 0.0079600000000000001 -1.4410818502126172e-06 0.0079700000000000014 1.6949458359276419e-06 0.007980000000000001 4.0577715603701412e-06 0.0079900000000000006 7.4018925268037403e-07 0.0080000000000000002 -5.0506067507417312e-06 0.0080100000000000015 2.6861629310359778e-06 0.0080200000000000011 -3.152663865900103e-06 0.0080300000000000007 -1.1171707378474257e-06 0.0080400000000000003 4.0922577754569146e-06 0.0080499999999999999 1.6584636668930522e-06 0.0080600000000000012 5.3638711804242005e-06 0.0080700000000000008 5.0208276063483243e-06 0.0080800000000000004 1.8549375215879007e-06 0.00809 2.3801382425284701e-06 0.0081000000000000013 5.0472958990334735e-06 0.0081100000000000009 4.2763829228910896e-06 0.0081200000000000005 1.723291069565363e-07 0.0081300000000000001 7.1187709878214824e-06 0.0081400000000000014 -9.2170047588853113e-07 0.008150000000000001 1.8322846943486752e-06 0.0081600000000000006 9.3471310961674611e-07 0.0081700000000000002 -5.3356168173590239e-06 0.0081800000000000015 -9.6549105392956144e-07 0.0081900000000000011 4.2160973647086205e-06 0.0082000000000000007 -2.3602931674700965e-06 0.0082100000000000003 3.4483879739021864e-06 0.0082199999999999999 -5.9856951889480993e-06 0.0082300000000000012 -3.4655890620862364e-07 0.0082400000000000008 3.3394066089801378e-06 0.0082500000000000004 -4.0850931108638405e-06 0.00826 -1.8745830226897887e-06 0.0082700000000000013 9.5508058336720973e-06 0.0082800000000000009 2.6265856538626187e-06 0.0082900000000000005 1.8128109106913331e-06 0.0083000000000000001 -2.8928251586277273e-06 0.0083100000000000014 3.5762276505115922e-07 0.008320000000000001 -8.3583291860737739e-06 0.0083300000000000006 7.2257585228974903e-06 0.0083400000000000002 -8.5710748706183634e-07 0.0083500000000000015 -3.7018555201137706e-06 0.0083600000000000011 -5.7726124042703239e-06 0.0083700000000000007 -6.3078921117946059e-06 0.0083800000000000003 1.4483732171388962e-06 0.0083899999999999999 2.8144837997395763e-06 0.0084000000000000012 4.0873494466058884e-06 0.0084100000000000008 6.8959424291090775e-06 0.0084200000000000004 -3.6817740525582446e-06 0.00843 3.3003957551912661e-06 0.0084400000000000013 1.0553668960185675e-06 0.0084500000000000009 -3.4467290867865584e-06 0.0084600000000000005 -5.0110511272995587e-06 0.0084700000000000001 5.8763308348606183e-06 0.0084800000000000014 6.9199781884437757e-06 0.008490000000000001 2.3085025776067334e-06 0.0085000000000000006 -4.950073074977951e-06 0.0085100000000000002 6.3189718795415159e-06 0.0085200000000000015 3.7881572895342766e-06 0.0085300000000000011 1.5156185347447055e-06 0.0085400000000000007 -7.8067754154484741e-06 0.0085500000000000003 2.7854523018453443e-06 0.0085599999999999999 -2.8399291427447568e-06 0.0085700000000000012 -3.9210342346071427e-06 0.0085800000000000008 -9.0015323900124591e-06 0.0085900000000000004 4.3378772493620307e-06 0.0086 -4.3254382438328299e-06 0.0086100000000000013 -2.9206738391321519e-06 0.0086200000000000009 9.8932874189196073e-06 0.0086300000000000005 -2.6137036210332452e-06 0.0086400000000000001 1.3263077162786992e-06 0.0086500000000000014 2.802907051443073e-07 0.008660000000000001 -5.0224531568590664e-06 0.0086700000000000006 8.9503597880306841e-07 0.0086800000000000002 -1.7789771690315136e-06 0.0086900000000000015 -8.183336526989168e-07 0.0087000000000000011 2.9113632195496637e-06 0.0087100000000000007 -1.1051761872340677e-07 0.0087200000000000003 -1.127366001683361e-06 0.0087299999999999999 -9.3829413794097266e-06 0.0087400000000000012 -6.1386996424732927e-06 0.0087500000000000008 4.7863655125732023e-06 0.0087600000000000004 -1.9121146277891235e-06 0.00877 -1.4202703800936942e-06 0.0087800000000000013 2.6626134328230104e-06 0.0087900000000000009 1.4986389981555215e-06 0.0088000000000000005 -5.9120305604811192e-06 0.0088100000000000001 6.7549975393778754e-07 0.0088200000000000014 5.2958089543367721e-06 0.008830000000000001 6.935330249409744e-06 0.0088400000000000006 1.0183967993723603e-05 0.0088500000000000002 1.5559778589011018e-06 0.0088600000000000016 1.0638220812849445e-06 0.0088700000000000011 -1.8477534477109191e-06 0.0088800000000000007 -7.7868949813216136e-07 0.0088900000000000003 1.9535158446483605e-07 0.0088999999999999999 -1.0014209807654791e-06 0.0089100000000000013 1.5995523512350927e-06 0.0089200000000000008 -4.3218422352541318e-07 0.0089300000000000004 4.6059664552726476e-06 0.00894 -6.4098605761410305e-06 0.0089500000000000014 -1.3606605278005979e-05 0.0089600000000000009 -1.0321962951449327e-06 0.0089700000000000005 -5.3376197786899641e-06 0.0089800000000000001 -2.8495161474956691e-06 0.0089900000000000015 -4.3371384841904094e-06 0.0090000000000000011 -6.3835300958094327e-06 0.0090100000000000006 2.9385265271535494e-06 0.0090200000000000002 3.8517415461046184e-06 0.0090300000000000016 9.638163390726982e-06 0.0090400000000000012 8.6640263812571256e-06 0.0090500000000000008 2.1559318638235109e-06 0.0090600000000000003 6.4626651988674508e-06 0.0090699999999999999 2.5905119447203057e-07 0.0090800000000000013 6.4565880217372558e-07 0.0090900000000000009 4.5758131824051026e-07 0.0091000000000000004 5.5145877287942561e-06 0.00911 1.7930492709950258e-07 0.0091200000000000014 -6.8288695173652087e-06 0.009130000000000001 -7.1783324546835367e-07 0.0091400000000000006 8.0067949700770524e-06 0.0091500000000000001 6.2823280043545709e-06 0.0091600000000000015 -4.6213879531292972e-06 0.0091700000000000011 -3.6773133395509159e-06 0.0091800000000000007 -5.4492656847868937e-06 0.0091900000000000003 -6.8207583213044328e-06 0.0092000000000000016 7.6905618612960526e-06 0.0092100000000000012 -7.8814511301670019e-07 0.0092200000000000008 1.8534625484194219e-06 0.0092300000000000004 1.6268773411474442e-06 0.0092399999999999999 1.0059379716851906e-05 0.0092500000000000013 6.3724371058283097e-06 0.0092600000000000009 -4.5533905779456847e-06 0.0092700000000000005 9.5114245302866901e-06 0.0092800000000000001 1.6343452186005033e-06 0.0092900000000000014 -3.0350441115363927e-06 0.009300000000000001 -6.1035473435019598e-06 0.0093100000000000006 1.0704192018673834e-06 0.0093200000000000002 6.8315551279717545e-10 0.0093300000000000015 -3.1137182614458798e-06 0.0093400000000000011 -2.1308428830780577e-06 0.0093500000000000007 2.9735611470568736e-06 0.0093600000000000003 5.6785397804012656e-06 0.0093700000000000016 -3.0078732437338203e-06 0.0093800000000000012 9.3610618283132324e-07 0.0093900000000000008 8.7212662827530065e-07 0.0094000000000000004 1.5505105337961604e-06 0.00941 3.8002927039144434e-06 0.0094200000000000013 -6.3723121432725333e-06 0.0094300000000000009 -1.1728475095277399e-06 0.0094400000000000005 -5.7745733977258815e-06 0.0094500000000000001 2.8357876329176544e-06 0.0094600000000000014 8.9196526961042535e-06 0.009470000000000001 3.994159024951154e-07 0.0094800000000000006 1.3603778022283299e-06 0.0094900000000000002 1.9998042668794043e-06 0.0095000000000000015 -2.8493673384975439e-06 0.0095100000000000011 -1.2896902971113115e-06 0.0095200000000000007 -8.2763445536043402e-06 0.0095300000000000003 -2.8667975784744428e-06 0.0095400000000000016 6.0919292272849159e-06 0.0095500000000000012 2.6865225919109385e-06 0.0095600000000000008 -9.7680748558286926e-07 0.0095700000000000004 -2.810445614751983e-06 0.00958 -3.7135116296278605e-06 0.0095900000000000013 -8.4280906982688772e-07 0.0096000000000000009 6.1052928471581902e-08 0.0096100000000000005 -3.4807298267033245e-06 0.0096200000000000001 1.0005056813136239e-06 0.0096300000000000014 7.7400477086259263e-06 0.009640000000000001 1.1572088417569553e-05 0.0096500000000000006 2.0395392120326468e-06 0.0096600000000000002 3.6404498491198195e-07 0.0096700000000000015 3.8287480495764631e-06 0.0096800000000000011 8.4900878999599108e-06 0.0096900000000000007 -1.1942896164942134e-06 0.0097000000000000003 7.9478657648997648e-07 0.0097100000000000016 -3.2856390031897558e-06 0.0097200000000000012 -3.8240561068419475e-06 0.0097300000000000008 1.8691814868971828e-06 0.0097400000000000004 -1.6715675199498581e-06 0.00975 -4.0660637789579956e-06 0.0097600000000000013 -4.6111265921309577e-06 0.0097700000000000009 3.3759133826608566e-06 0.0097800000000000005 6.2732423506574348e-06 0.0097900000000000001 -1.8050762518972084e-06 0.0098000000000000014 4.7269123570303664e-06 0.009810000000000001 -9.0293173794168316e-07 0.0098200000000000006 2.1677086393194737e-07 0.0098300000000000002 -1.86315733827945e-06 0.0098400000000000015 -3.9311632986724165e-06 0.0098500000000000011 3.4964326250636882e-06 0.0098600000000000007 5.9004330212679052e-06 0.0098700000000000003 -3.9625122661253007e-06 0.0098800000000000016 -5.340903307214924e-08 0.0098900000000000012 8.1458140144944134e-06 0.0099000000000000008 -2.4005053565531588e-06 0.0099100000000000004 6.2790038292103182e-07 0.00992 -1.1909321431903435e-06 0.0099300000000000013 -6.6447373242583971e-06 0.0099400000000000009 3.6878360218537018e-06 0.0099500000000000005 -2.7844078625678205e-07 0.0099600000000000001 -2.3037321000009746e-06 0.0099700000000000014 1.3387723308277519e-06 0.009980000000000001 -4.4559255516744356e-06 0.0099900000000000006 -1.8331552342157072e-06 0.01 6.6282751918726337e-06 0.010010000000000002 -1.5493778305863583e-06 0.010020000000000001 -3.3281311398251218e-06 0.010030000000000001 -1.8240473315848509e-07 0.01004 9.5051557433244731e-06 0.010050000000000002 1.4987882856514563e-06 0.010060000000000001 -5.3915818616976523e-06 0.010070000000000001 6.2135032288358358e-07 0.01008 -3.8238461182027258e-06 0.01009 -3.6929492134702379e-06 0.010100000000000001 7.9326803463380076e-06 0.010110000000000001 6.2703059640709229e-06 0.010120000000000001 -2.1848717138147337e-06 0.01013 -4.9287802113067297e-06 0.010140000000000001 1.7539654898360809e-06 0.010150000000000001 9.6661245743057752e-07 0.010160000000000001 -4.2707355515171216e-06 0.01017 -9.4273327021101496e-06 0.010180000000000002 5.684140983817203e-07 0.010190000000000001 -8.3997016772227242e-06 0.010200000000000001 3.4377250033619468e-06 0.01021 -2.9464693479275315e-06 0.010220000000000002 -2.5278871198837374e-06 0.010230000000000001 9.925200566805746e-07 0.010240000000000001 -3.9978282558918543e-06 0.01025 9.6586288968730952e-07 0.01026 4.5190522323287335e-07 0.010270000000000001 -4.0407834504739725e-07 0.010280000000000001 2.0532809103455521e-06 0.010290000000000001 5.74597506556402e-06 0.0103 -3.9171348490969402e-06 0.010310000000000001 6.4134199517143818e-07 0.010320000000000001 -3.2485769164973425e-07 0.010330000000000001 -8.0123696959296216e-06 0.01034 -7.9563811089692931e-06 0.010350000000000002 7.3195731943130796e-06 0.010360000000000001 1.338147425131783e-08 0.010370000000000001 7.6651022385718867e-07 0.01038 5.3969298904905656e-06 0.010390000000000002 -1.483834263658617e-06 0.010400000000000001 -7.8200786726882029e-06 0.010410000000000001 1.0408534031994734e-06 0.01042 -3.1989258248779124e-06 0.01043 -2.7143526442871128e-06 0.010440000000000001 5.1795257125280126e-06 0.010450000000000001 -1.3018371591464585e-05 0.010460000000000001 -2.3001105710950656e-06 0.01047 7.9479689313713435e-06 0.010480000000000001 4.2884828999865143e-06 0.010490000000000001 8.8948753705473616e-06 0.010500000000000001 3.4165754202701885e-06 0.01051 6.1234587325262105e-06 0.010520000000000002 2.9631962382124833e-06 0.010530000000000001 -1.4755091366363464e-06 0.010540000000000001 3.245789479901481e-06 0.01055 3.2993248951774285e-06 0.010560000000000002 -5.9786334987336245e-06 0.010570000000000001 -1.0579554403627838e-06 0.010580000000000001 6.2909967047522681e-06 0.01059 9.4709205014005186e-06 0.0106 9.8040344048521028e-07 0.010610000000000001 4.8160094245214958e-06 0.010620000000000001 2.2084095838051688e-06 0.010630000000000001 -3.6931784724624333e-06 0.01064 6.4729663476060399e-06 0.010650000000000001 1.4107574937044305e-06 0.010660000000000001 4.0755100991823752e-06 0.010670000000000001 3.9393904826827356e-06 0.01068 9.4559764375196799e-06 0.010690000000000002 2.9640373151690499e-07 0.010700000000000001 6.9919125952124037e-06 0.010710000000000001 -8.0886010398645426e-07 0.01072 3.2529874170256948e-06 0.010730000000000002 -7.3008212082345632e-06 0.010740000000000001 2.3785537019472535e-06 0.010750000000000001 -1.3017323028949655e-06 0.01076 -2.930209300525333e-06 0.01077 6.7302624489180871e-06 0.010780000000000001 -6.187061290443049e-07 0.010790000000000001 5.7535771064372062e-06 0.010800000000000001 2.3061386726592247e-07 0.01081 -6.0359154233927275e-06 0.010820000000000001 9.1599556049847231e-06 0.010830000000000001 1.6835859338637254e-06 0.010840000000000001 -6.157758859654563e-06 0.01085 -8.9526958205277504e-07 0.010860000000000002 5.3714013066184198e-06 0.010870000000000001 4.9712734594510066e-06 0.010880000000000001 -3.3879323462477356e-06 0.01089 7.2091550559746669e-06 0.010900000000000002 -4.1912139953974633e-06 0.010910000000000001 3.2011150607200849e-06 0.010920000000000001 3.1859921620049528e-06 0.01093 8.8796659187400155e-06 0.01094 -1.3209463262608197e-06 0.010950000000000001 -1.1559142367000998e-05 0.010960000000000001 6.8144583068269802e-06 0.010970000000000001 -2.0219525094171801e-06 0.01098 -5.5358922494863883e-06 0.010990000000000002 -1.023085640024868e-06 0.011000000000000001 4.7038088714156309e-06 0.011010000000000001 6.3283924261399041e-07 0.01102 -3.0789366022278073e-06 0.011030000000000002 -2.6759043993827001e-06 0.011040000000000001 -7.4160793090045689e-07 0.011050000000000001 1.3442463037012308e-06 0.01106 3.5942048832749798e-06 0.011070000000000002 -2.611686469206728e-06 0.011080000000000001 2.3861252617382273e-06 0.011090000000000001 -8.4810528710495934e-07 0.0111 1.8721254304676841e-06 0.01111 2.3774999593052233e-06 0.011120000000000001 1.2651869149901657e-05 0.011130000000000001 4.5044721882261181e-06 0.011140000000000001 5.8167422922934082e-06 0.01115 -3.3603636160327096e-07 0.011160000000000002 1.07178661777851e-05 0.011170000000000001 3.3817516672022758e-07 0.011180000000000001 -4.5924264631120525e-06 0.01119 -8.5690998005251223e-07 0.011200000000000002 -5.4742920534461519e-06 0.011210000000000001 -3.9306391382183138e-06 0.011220000000000001 2.6160902090041036e-06 0.01123 -2.4721116934374461e-07 0.011240000000000002 -9.8619199807265424e-08 0.011250000000000001 -4.9564767696091901e-06 0.011260000000000001 -8.7946517213356143e-06 0.011270000000000001 7.9165299069154292e-07 0.01128 8.5896979510798947e-06 0.011290000000000001 4.3449585417002635e-06 0.011300000000000001 1.2611089802600699e-06 0.011310000000000001 -2.1428142503783953e-06 0.01132 -7.4224633485556554e-07 0.011330000000000002 -3.3994933806406207e-06 0.011340000000000001 -6.8114476179818761e-07 0.011350000000000001 3.4965846892493516e-06 0.01136 1.9810959779160904e-06 0.011370000000000002 1.0511192263601568e-05 0.011380000000000001 -7.079861686061752e-06 0.011390000000000001 -2.8539044343399826e-06 0.0114 2.9442071465134621e-06 0.011410000000000002 1.0753028254725331e-06 0.011420000000000001 2.4441427545941579e-06 0.011430000000000001 7.4427233036824556e-06 0.011440000000000001 -1.1289192138072357e-05 0.01145 8.1828231757349994e-07 0.011460000000000001 3.3349206898076557e-06 0.011470000000000001 -6.2205338560605586e-06 0.011480000000000001 -6.8824299822333373e-06 0.01149 8.5345078621836987e-06 0.011500000000000002 2.9549178084895496e-06 0.011510000000000001 2.5697057590805041e-06 0.011520000000000001 9.6864634917735411e-06 0.01153 -7.8738090717949263e-06 0.011540000000000002 2.0191989144630379e-06 0.011550000000000001 -1.7337180816422933e-06 0.011560000000000001 2.3174499321340331e-06 0.01157 3.4711117950446854e-06 0.011580000000000002 1.5691921599193204e-06 0.011590000000000001 1.0515878313775205e-05 0.011600000000000001 5.1538250745035719e-06 0.011610000000000001 3.2491783706471101e-06 0.01162 -3.2817260420255771e-06 0.011630000000000001 -7.8276035504564082e-06 0.011640000000000001 -7.3646912304811534e-06 0.011650000000000001 -4.3334414878177257e-06 0.01166 -1.8017992991831188e-07 0.011670000000000002 -7.0897627308022575e-06 0.011680000000000001 7.1110484087679197e-06 0.011690000000000001 -7.9103859383570974e-06 0.0117 -1.097023056814937e-05 0.011710000000000002 8.3344516683498483e-06 0.011720000000000001 4.7933271404545714e-06 0.011730000000000001 -2.350056724921041e-07 0.01174 -6.7684144996965709e-07 0.011750000000000002 3.2997471650677226e-06 0.011760000000000001 5.9103369092976939e-06 0.011770000000000001 -7.4902088198108915e-06 0.011780000000000001 3.028974519101205e-07 0.01179 -3.6940749366036012e-06 0.011800000000000001 -4.0981228213954724e-06 0.011810000000000001 2.3625177289202007e-06 0.011820000000000001 4.5925092922456886e-06 0.01183 9.5268982692822277e-06 0.011840000000000002 -1.3769235173318283e-06 0.011850000000000001 -2.3880243866392083e-07 0.011860000000000001 -2.3614848320312307e-06 0.01187 -5.2716441196888725e-06 0.011880000000000002 -2.8604698881483879e-06 0.011890000000000001 9.0266977443652743e-06 0.011900000000000001 1.4726658829823986e-06 0.01191 5.0598152385443104e-07 0.011920000000000002 -3.3833491382060552e-06 0.011930000000000001 -1.1100520683958747e-05 0.011940000000000001 8.3298065995024313e-06 0.011950000000000001 -3.9354045286572848e-06 0.01196 5.6079226703257727e-06 0.011970000000000001 -2.9843882291659597e-06 0.011980000000000001 5.9464477718812244e-06 0.011990000000000001 2.3237227517045175e-06 0.012 3.3485174077288019e-06 0.012010000000000002 1.6721255795281458e-06 0.012020000000000001 -9.8941892983506971e-06 0.012030000000000001 -7.6086435773683288e-07 0.01204 -3.2330913934927259e-06 0.012050000000000002 -2.4136662684371218e-06 0.012060000000000001 -8.5064493034209858e-06 0.012070000000000001 -3.7232119622200356e-06 0.01208 -2.2079126554604263e-06 0.012090000000000002 -4.4594756394835953e-06 0.012100000000000001 3.7473554145062946e-06 0.012110000000000001 -7.7471362465027677e-07 0.012120000000000001 3.3528010651931318e-06 0.01213 1.2223213254384186e-06 0.012140000000000001 -2.7009371058515812e-06 0.012150000000000001 4.3464201445838884e-06 0.012160000000000001 6.3276477387672674e-06 0.01217 -6.5192370127334884e-06 0.012180000000000002 5.7515275751577257e-06 0.012190000000000001 4.686974099794973e-06 0.012200000000000001 -7.7816150790557038e-06 0.01221 3.2277400515029122e-07 0.012220000000000002 -5.2656568910615995e-06 0.012230000000000001 5.4757956979398662e-06 0.012240000000000001 6.1562689314209414e-07 0.01225 -1.8229210173838368e-07 0.012260000000000002 -7.0232825108053933e-08 0.012270000000000001 3.1249280656052512e-06 0.012280000000000001 -4.1186461307441397e-06 0.012290000000000001 7.432781011359502e-06 0.0123 1.2969779452266548e-06 0.012310000000000001 -9.2673698225641885e-07 0.012320000000000001 7.8177724192030718e-06 0.012330000000000001 5.7078297654955364e-06 0.01234 -8.6930073406615357e-06 0.012350000000000002 -1.2059007181302851e-06 0.012360000000000001 6.0699408377346146e-07 0.012370000000000001 -3.5161792761534736e-06 0.01238 1.962789239701469e-07 0.012390000000000002 4.4794768186768042e-07 0.012400000000000001 1.542785464052671e-05 0.012410000000000001 -4.6584253456102331e-06 0.01242 -3.6329218579097125e-06 0.012430000000000002 9.8005878408789904e-06 0.012440000000000001 -4.998503184818406e-06 0.012450000000000001 -8.0263135325124751e-07 0.012460000000000001 -2.101616758179529e-06 0.01247 7.2672701111280396e-06 0.012480000000000002 1.7644201336486327e-06 0.012490000000000001 -1.1385418228188608e-05 0.012500000000000001 3.7960094073668145e-06 0.01251 2.7548559882165932e-06 0.012520000000000002 -3.5014682698334167e-06 0.012530000000000001 -7.1787385745765844e-08 0.012540000000000001 8.9890041299222341e-06 0.01255 -5.8736292287642962e-06 0.012560000000000002 -9.9458828972561343e-06 0.012570000000000001 3.9390810595798645e-06 0.012580000000000001 3.3072995589511536e-06 0.01259 -7.4244478533211638e-06 0.012600000000000002 -2.2311999648226931e-07 0.012610000000000001 3.6651549700931622e-06 0.012620000000000001 -7.8094884342433476e-07 0.012630000000000001 3.4532477329098025e-06 0.01264 -5.7121203100544076e-06 0.012650000000000002 -5.5738191856582627e-06 0.012660000000000001 3.6560966268155414e-06 0.012670000000000001 -6.5182338209576283e-06 0.01268 -5.53033289503041e-06 0.012690000000000002 4.9370547349356377e-06 0.012700000000000001 1.3732245728270027e-07 0.012710000000000001 -1.1816666023266559e-05 0.01272 6.8431613614852041e-06 0.012730000000000002 4.2401377788946208e-06 0.012740000000000001 6.287475687325757e-06 0.012750000000000001 -1.0398590619001049e-06 0.012760000000000001 4.9413917527791148e-06 0.012770000000000002 2.9399998763630584e-06 0.012780000000000001 -3.9973712889891347e-06 0.012790000000000001 1.6008123712282759e-06 0.012800000000000001 -7.468701421498197e-07 0.01281 1.5330784526846035e-06 0.012820000000000002 -9.0462307591736649e-09 0.012830000000000001 -6.4450944349524346e-06 0.012840000000000001 -2.091028779982071e-06 0.01285 4.6393039831973201e-06 0.012860000000000002 4.7957697827668466e-06 0.012870000000000001 -2.6158141716800301e-06 0.012880000000000001 3.7362620550416391e-06 0.01289 4.526517466006857e-06 0.012900000000000002 -1.2078706744571295e-06 0.012910000000000001 -2.5410703764230072e-06 0.012920000000000001 -1.4303553114521073e-06 0.012930000000000001 -1.490069267099855e-05 0.012940000000000002 2.9935819805593825e-06 0.012950000000000001 -3.0342885760842377e-08 0.012960000000000001 4.0147699103296995e-06 0.012970000000000001 2.8492801623249174e-06 0.01298 1.3860549810141243e-06 0.012990000000000002 -2.7574423294281427e-06 0.013000000000000001 4.5569098043519658e-06 0.013010000000000001 1.4448164665404753e-06 0.01302 -2.6764055517872568e-06 0.013030000000000002 2.8173472613268584e-08 0.013040000000000001 -9.0208125123719154e-07 0.013050000000000001 -1.0135785841364348e-05 0.01306 -6.6952358893434964e-06 0.013070000000000002 1.1804997777340429e-07 0.013080000000000001 -2.1017288712906802e-07 0.013090000000000001 8.1581309748860039e-06 0.013100000000000001 7.0413818295340993e-06 0.013110000000000002 8.7761638734856869e-07 0.013120000000000001 -4.3499626597132161e-07 0.013130000000000001 1.0514202031585332e-05 0.013140000000000001 -3.7574374843294126e-06 0.01315 -2.7677088329968498e-06 0.013160000000000002 -8.5307455985938497e-06 0.013170000000000001 -3.1378217812583937e-06 0.013180000000000001 5.8256517270075393e-06 0.01319 -1.3839757580256955e-07 0.013200000000000002 9.2264570465971912e-06 0.013210000000000001 -4.9966343345700345e-06 0.013220000000000001 1.3242598884725489e-05 0.01323 -6.5915721120107247e-07 0.013240000000000002 -5.1282737324313266e-06 0.013250000000000001 7.5170994587938665e-07 0.013260000000000001 5.63433538480089e-06 0.013270000000000001 -2.0899266256432004e-06 0.013280000000000002 6.7775163611123787e-06 0.013290000000000001 -4.5381616199140669e-06 0.013300000000000001 -6.0743447162925529e-06 0.013310000000000001 -1.7737020034680125e-07 0.01332 -1.2161152043396494e-06 0.013330000000000002 1.6411617735818187e-06 0.013340000000000001 4.3302802131401246e-06 0.013350000000000001 -2.1680615930478103e-06 0.01336 3.0239399489310798e-06 0.013370000000000002 -1.2410354561880872e-06 0.013380000000000001 8.8628441774764481e-06 0.013390000000000001 3.261364779859586e-06 0.0134 -9.175665055308592e-06 0.013410000000000002 -4.9100687814782424e-06 0.013420000000000001 -6.2488845549272555e-06 0.013430000000000001 3.3423049391128297e-07 0.013440000000000001 3.7397542678525166e-06 0.013450000000000002 -1.6198518858518079e-06 0.013460000000000001 -6.6589808726448845e-06 0.013470000000000001 2.2433404177106909e-06 0.013480000000000001 1.0804969933261501e-06 0.01349 -2.3419976590213269e-06 0.013500000000000002 -5.1675645837502563e-06 0.013510000000000001 -4.0848121723980148e-06 0.013520000000000001 2.2466468004236365e-06 0.01353 9.9809406711588622e-06 0.013540000000000002 -1.0190115652833306e-06 0.013550000000000001 5.9713048754992282e-07 0.013560000000000001 7.3322709885531838e-07 0.01357 1.0991183365857576e-05 0.013580000000000002 -3.1879051533447009e-06 0.013590000000000001 -1.3029571256437772e-05 0.013600000000000001 -5.4785962810881498e-06 0.013610000000000001 -1.0799194803718697e-06 0.013620000000000002 7.1758981753701077e-07 0.013630000000000001 -4.1602815972575919e-06 0.013640000000000001 -2.1321286352301902e-06 0.013650000000000001 -3.1883735728933064e-07 0.01366 -1.7979412820298719e-06 0.013670000000000002 -6.2785084379517416e-06 0.013680000000000001 -2.6742344368979389e-06 0.013690000000000001 -1.2773833165631214e-06 0.0137 2.862512315049213e-06 0.013710000000000002 3.0099708139143114e-06 0.013720000000000001 -5.5334591570698578e-06 0.013730000000000001 1.9230781197368125e-08 0.01374 -2.5575941872624289e-07 0.013750000000000002 1.0059394521113485e-07 0.013760000000000001 -9.0295340187393387e-06 0.013770000000000001 7.7873611268220023e-06 0.013780000000000001 -5.6966406014576714e-06 0.013790000000000002 -3.3754483865120779e-06 0.013800000000000002 5.7222562077302122e-06 0.013810000000000001 -1.101383188414591e-06 0.013820000000000001 -1.0307739276601799e-06 0.01383 3.5401799115575684e-06 0.013840000000000002 4.2004693804567152e-06 0.013850000000000001 -4.8778735996751623e-06 0.013860000000000001 -1.2058978309738022e-05 0.01387 -8.1548248025984603e-06 0.013880000000000002 1.8369067907704984e-06 0.013890000000000001 -4.0239791528300637e-07 0.013900000000000001 9.3698421579102205e-07 0.01391 -2.6829259222770475e-06 0.013920000000000002 -2.7812073377026765e-06 0.013930000000000001 3.7495734022086119e-06 0.013940000000000001 -1.3656452518394586e-06 0.013950000000000001 2.4404154595803682e-06 0.013960000000000002 3.0934006763994538e-06 0.013970000000000002 -4.4930890329162629e-06 0.013980000000000001 -4.0471138532779589e-06 0.013990000000000001 -3.9868376966281283e-06 0.014 -9.9796687729801528e-06 0.014010000000000002 -1.8881545410452044e-06 0.014020000000000001 -1.2254207174533223e-06 0.014030000000000001 -1.0235868413024912e-05 0.01404 4.5106401077900221e-06 0.014050000000000002 -4.8425818034932537e-06 0.014060000000000001 -4.4125014376318871e-06 0.014070000000000001 5.9343920567769531e-06 0.014080000000000001 -4.4868496924623837e-06 0.014090000000000002 1.8966549724306069e-06 0.014100000000000001 -8.6952326939194398e-07 0.014110000000000001 6.849587773510611e-06 0.014120000000000001 -5.6819459205071359e-06 0.014130000000000002 8.3717195671412133e-06 0.014140000000000002 3.046137548112742e-06 0.014150000000000001 -1.0079312883374436e-06 0.014160000000000001 -1.5640097354829505e-07 0.01417 7.7739958630643859e-06 0.014180000000000002 -6.9836874810135021e-06 0.014190000000000001 7.3400706525535967e-07 0.014200000000000001 -2.3410434090987712e-06 0.01421 3.7621769625432147e-06 0.014220000000000002 -4.7939773133322245e-06 0.014230000000000001 -6.1636328877213673e-06 0.014240000000000001 -2.3812283612194282e-06 0.014250000000000001 3.5661012408606184e-06 0.014260000000000002 2.417647382045324e-06 0.014270000000000001 1.1827140273499544e-05 0.014280000000000001 2.4242404677178765e-06 0.014290000000000001 1.0991229672280123e-06 0.014300000000000002 5.6389733497441969e-07 0.014310000000000002 1.1487376503191012e-05 0.014320000000000001 3.2225738463727886e-06 0.014330000000000001 5.4815247145520542e-06 0.01434 -1.4095982959922149e-06 0.014350000000000002 6.9680429205968845e-06 0.014360000000000001 -7.0077914373722814e-06 0.014370000000000001 -7.9941604591924131e-06 0.01438 -2.3213446199403284e-06 0.014390000000000002 -2.0298972127415535e-06 0.014400000000000001 -4.5069523144800744e-06 0.014410000000000001 -5.8089514399933178e-07 0.014420000000000001 3.8221790442564157e-06 0.014430000000000002 5.2551100744447143e-07 0.014440000000000001 -1.375607840201553e-06 0.014450000000000001 -8.7351196937978669e-07 0.014460000000000001 1.1475734427173819e-05 0.014470000000000002 1.2374506041157191e-06 0.014480000000000002 1.1635788455093242e-07 0.014490000000000001 2.0465408785595399e-06 0.014500000000000001 -5.3429077046974879e-07 0.01451 3.1774115779150643e-06 0.014520000000000002 -3.2506474970361057e-06 0.014530000000000001 -1.0549294748914999e-06 0.014540000000000001 9.5450114494090369e-06 0.01455 3.468520800645694e-06 0.014560000000000002 -3.9781009142507249e-06 0.014570000000000001 -5.3162992507523794e-06 0.014580000000000001 3.9957036253172456e-06 0.014590000000000001 -6.6329823548699825e-06 0.014600000000000002 -4.1136555803203778e-06 0.014610000000000001 7.9493428264016761e-06 0.014620000000000001 5.7571727402281715e-06 0.014630000000000001 -6.3577945635880359e-06 0.014640000000000002 -1.1184551521898846e-06 0.014650000000000002 -4.740874286122386e-06 0.014660000000000001 -5.6326632921621364e-07 0.014670000000000001 -6.8361085671583375e-06 0.01468 -6.9770590388651115e-06 0.014690000000000002 -2.6067194735234568e-06 0.014700000000000001 4.2225248972311339e-06 0.014710000000000001 -1.7542512597104328e-06 0.01472 -1.3601686225507466e-06 0.014730000000000002 -8.8308952402453925e-07 0.014740000000000001 9.5310119845310407e-06 0.014750000000000001 -2.5611473906031173e-07 0.014760000000000001 -2.148297204258646e-06 0.014770000000000002 1.6785824528708297e-06 0.014780000000000001 1.3016798474760766e-05 0.014790000000000001 4.016321660204629e-06 0.014800000000000001 -6.7108269510242415e-06 0.014810000000000002 -3.0997432323381765e-06 0.014820000000000002 3.0365277674660613e-06 0.014830000000000001 4.2810659207204367e-06 0.014840000000000001 1.0899891319970895e-06 0.01485 7.889829857105988e-06 0.014860000000000002 -5.2523009545726285e-06 0.014870000000000001 -9.0985778346624597e-06 0.014880000000000001 -2.8681265638453486e-06 0.01489 3.3575004948251688e-06 0.014900000000000002 -6.0950748698157629e-07 0.014910000000000001 7.4012935983743564e-07 0.014920000000000001 -6.2558719345108519e-07 0.014930000000000001 5.4340084915752247e-06 0.014940000000000002 -1.0061233293414784e-05 0.014950000000000001 2.5841843506981097e-06 0.014960000000000001 5.17493628460798e-06 0.014970000000000001 -1.0124411811268058e-05 0.014980000000000002 -3.1857649659828953e-06 0.014990000000000002 4.9873958327305431e-06 0.015000000000000001 3.9042398284908419e-06 0.015010000000000001 -2.2524200019604954e-06 0.01502 -3.669238916281262e-06 0.015030000000000002 -4.8275809542746364e-07 0.015040000000000001 -7.7830735261465917e-06 0.015050000000000001 -5.7154056802467803e-06 0.01506 -1.5993861909981514e-06 0.015070000000000002 -9.299064228528473e-06 0.015080000000000001 4.5368993281411019e-06 0.015090000000000001 6.5515669340799783e-06 0.015100000000000001 6.5286732868718279e-07 0.015110000000000002 3.9529194764224948e-06 0.015120000000000001 -5.4543269375766315e-06 0.015130000000000001 -3.6561536454181045e-06 0.015140000000000001 -2.4921757758926448e-06 0.015150000000000002 4.4786853341775469e-06 0.015160000000000002 3.1281606231401975e-06 0.015170000000000001 1.2983514643081163e-05 0.015180000000000001 -6.5494438756335594e-07 0.01519 3.8477091518546786e-06 0.015200000000000002 -3.1398504092099598e-06 0.015210000000000001 1.3818962584073788e-06 0.015220000000000001 2.5296238851153858e-06 0.01523 1.5042089733894075e-05 0.015240000000000002 -4.6653184549307701e-06 0.015250000000000001 5.2815074883332332e-06 0.015260000000000001 -5.4412768384056072e-07 0.015270000000000001 6.6682529850389485e-06 0.015280000000000002 7.2111306465136963e-07 0.015290000000000002 7.1079856481553033e-07 0.015300000000000001 3.4466792594119928e-06 0.015310000000000001 6.0094475382595206e-06 0.015320000000000002 2.7362308730898022e-06 0.015330000000000002 9.7603903248109839e-07 0.015340000000000001 -5.8515177718067328e-06 0.015350000000000001 -1.2934666870682486e-06 0.015360000000000002 4.5449527984364119e-07 0.015370000000000002 1.8704623260492866e-06 0.015380000000000001 -8.4197081998275893e-07 0.015390000000000001 1.2639956722459359e-06 0.0154 -1.3834432059799054e-06 0.015410000000000002 -8.1051389566920505e-06 0.015420000000000001 3.629539551991622e-06 0.015430000000000001 1.2045609416051124e-07 0.015440000000000001 3.7923343622116736e-06 0.015450000000000002 -3.5927645808123762e-06 0.015460000000000002 -3.2905122190449212e-06 0.015470000000000001 -6.5663340733793094e-06 0.015480000000000001 1.1424922638603052e-06 0.015490000000000002 -2.2696565583158448e-06 0.015500000000000002 -5.5570070815548837e-06 0.015510000000000001 -6.01999155912008e-06 0.015520000000000001 2.2337062257623075e-06 0.015530000000000002 7.1827766232365404e-06 0.015540000000000002 1.0315490570594089e-06 0.015550000000000001 3.1564202259315439e-06 0.015560000000000001 -1.4345494547913677e-06 0.015570000000000001 -2.6421923339540449e-06 0.015580000000000002 3.6218392004133695e-06 0.015590000000000001 -7.7633303248282391e-06 0.015600000000000001 2.5715117084157044e-07 0.015610000000000001 6.4810935297853217e-06 0.015620000000000002 1.8795711274365569e-06 0.015630000000000002 -9.1053386713567822e-06 0.015640000000000001 -3.0815706988449743e-06 0.015650000000000001 2.8862655754215918e-07 0.01566 -7.6488765779013369e-06 0.01567 -2.9341661357735747e-06 0.015680000000000003 -1.7106530097140802e-06 0.015690000000000003 1.1763597621206273e-05 0.015700000000000002 -1.417649815876167e-06 0.015710000000000002 -1.053613162740737e-07 0.015720000000000001 -3.7350742256494752e-06 0.015730000000000001 5.3973476811437564e-06 0.015740000000000001 -1.6271761669452352e-06 0.01575 -1.1907090697955514e-06 0.01576 -2.3311641444705557e-07 0.015770000000000003 2.6513592788208838e-06 0.015780000000000002 1.2370294894300474e-06 0.015790000000000002 4.2292314760337495e-06 0.015800000000000002 1.4033304530106584e-06 0.015810000000000001 -1.3381430001017026e-07 0.015820000000000001 4.5081355013553871e-06 0.01583 -3.5922397411761106e-06 0.01584 -7.6579308760241495e-06 0.015850000000000003 -1.296406742658208e-06 0.015860000000000003 -6.0254310344720977e-06 0.015870000000000002 -2.7899246193551456e-07 0.015880000000000002 6.1481414676053052e-06 0.015890000000000001 1.5590583968231457e-06 0.015900000000000001 1.7288727567181094e-07 0.015910000000000001 5.0730149866037984e-06 0.01592 -6.8443881115584084e-08 0.01593 -2.289863424523475e-06 0.015940000000000003 -2.9604548944226482e-06 0.015950000000000002 5.9064018738851446e-06 0.015960000000000002 -2.5272736762928707e-06 0.015970000000000002 3.8885005790436144e-06 0.015980000000000001 4.9982603496708612e-06 0.015990000000000001 -1.3893100885971952e-06 0.016 3.6131621894717855e-07 0.01601 4.7984602665330941e-06 0.016020000000000003 -5.8431541809474991e-06 0.016030000000000003 4.0660365840582931e-06 0.016040000000000002 3.0462756933237188e-06 0.016050000000000002 2.0487688727736565e-06 0.016060000000000001 -6.8756230555847993e-06 0.016070000000000001 1.010578535971684e-05 0.016080000000000001 -1.5955471088038561e-06 0.01609 -2.6728214052273509e-06 0.0161 4.3095386437850112e-06 0.016110000000000003 4.3108067244712541e-06 0.016120000000000002 3.2395361235300045e-06 0.016130000000000002 -1.633968056323673e-06 0.016140000000000002 -6.5073737624920872e-06 0.016150000000000001 -6.6679482862784148e-06 0.016160000000000001 1.4477710301524558e-06 0.01617 -1.461845400642749e-06 0.01618 3.6438436190567437e-06 0.016190000000000003 -2.8479060378378952e-06 0.016200000000000003 6.0857531331426255e-06 0.016210000000000002 -4.4485741906464411e-07 0.016220000000000002 2.2686261035178549e-06 0.016230000000000001 -8.2054147287450694e-08 0.016240000000000001 -4.7849446416526255e-06 0.016250000000000001 5.6587759730295097e-06 0.01626 -3.6007869546989053e-06 0.01627 2.7586310494001693e-06 0.016280000000000003 -4.3083923458094965e-06 0.016290000000000002 -1.203294080362615e-05 0.016300000000000002 1.2089518854821441e-07 0.016310000000000002 -1.3329260226566989e-05 0.016320000000000001 6.5883165154432227e-06 0.016330000000000001 -7.628069842996261e-06 0.01634 2.5029785256160855e-06 0.01635 -1.8962299438624349e-07 0.016360000000000003 -5.2049200073637627e-06 0.016370000000000003 4.4909757246621311e-06 0.016380000000000002 -3.0415320792670233e-06 0.016390000000000002 -8.6593233458347329e-06 0.016400000000000001 -1.9089084112494844e-06 0.016410000000000001 -5.5074592913586643e-06 0.016420000000000001 -1.8387550782430228e-06 0.01643 7.019809925976244e-06 0.01644 6.9812546131180247e-06 0.016450000000000003 9.8123820108812904e-06 0.016460000000000002 -1.1506312034515078e-06 0.016470000000000002 4.2547534709814876e-07 0.016480000000000002 -7.7698413190577128e-06 0.016490000000000001 -1.2321208594152233e-05 0.016500000000000001 2.2192590170370403e-06 0.01651 5.9221480671683874e-07 0.01652 -3.089141137938539e-06 0.016530000000000003 -4.6610341760710851e-07 0.016540000000000003 4.0073147084626563e-06 0.016550000000000002 -3.6909362103976408e-06 0.016560000000000002 3.3562533929820075e-06 0.016570000000000001 -5.8690761944063099e-06 0.016580000000000001 3.0251603683576366e-07 0.016590000000000001 1.3951423325818429e-05 0.0166 -3.7592969759356367e-06 0.01661 1.3365082721764619e-06 0.016620000000000003 4.8928142917471468e-06 0.016630000000000002 1.6403555319946709e-06 0.016640000000000002 -2.6752953654040627e-06 0.016650000000000002 -3.6060990099785464e-06 0.016660000000000001 3.0911403808001394e-06 0.016670000000000001 7.0287629101575296e-07 0.01668 1.034563086622536e-05 0.01669 -6.7285333144788798e-06 0.016700000000000003 -2.4766473890132552e-06 0.016710000000000003 -3.7568615224640885e-06 0.016720000000000002 1.4889797526149289e-06 0.016730000000000002 -1.5355775237244582e-07 0.016740000000000001 9.6538605017918011e-06 0.016750000000000001 1.2894166948974698e-06 0.016760000000000001 5.3985521323379482e-06 0.01677 2.2594905550201889e-06 0.01678 6.4370048534780663e-06 0.016790000000000003 -6.9189156041327565e-06 0.016800000000000002 -3.313135326281221e-06 0.016810000000000002 4.2021670100087521e-06 0.016820000000000002 -2.5703685711311414e-08 0.016830000000000001 -3.5667553734030069e-06 0.016840000000000001 -3.3006346668193633e-06 0.01685 -2.1527035382619603e-06 0.01686 1.4808309518650985e-06 0.016870000000000003 -4.7338457436536095e-06 0.016880000000000003 -2.045025018050804e-06 0.016890000000000002 -2.4247484769113129e-06 0.016900000000000002 4.7818970721318715e-06 0.016910000000000001 -5.3214649402829252e-06 0.016920000000000001 -8.1226567707502771e-06 0.016930000000000001 4.1525465716667582e-06 0.01694 2.3799260854581465e-06 0.01695 4.79481789432681e-06 0.016960000000000003 2.975156288979011e-06 0.016970000000000002 4.1789855029535722e-06 0.016980000000000002 2.2232242437994141e-06 0.016990000000000002 1.7508165277286194e-06 0.017000000000000001 3.999388385023046e-06 0.017010000000000001 3.1555641219735082e-06 0.01702 -1.0942308324048945e-06 0.01703 5.1831788235746879e-06 0.017040000000000003 -1.0011649447440414e-05 0.017050000000000003 -9.1198216233006777e-06 0.017060000000000002 -8.2922678884710356e-06 0.017070000000000002 -2.074780316544049e-06 0.017080000000000001 4.0968226354218346e-07 0.017090000000000001 3.6883182481447999e-06 0.017100000000000001 2.5382012726723499e-07 0.01711 9.5150676096627511e-06 0.01712 4.0322872567131813e-06 0.017130000000000003 5.2588167651952505e-07 0.017140000000000002 7.773077947602223e-07 0.017150000000000002 -9.0872215070516158e-06 0.017160000000000002 3.5538013627301147e-06 0.017170000000000001 -1.5853791413620097e-06 0.017180000000000001 2.6138844570176576e-06 0.01719 7.916725684604305e-06 0.0172 -4.8568857267218291e-07 0.017210000000000003 -4.1668980870920083e-07 0.017220000000000003 -3.9065983202945886e-06 0.017230000000000002 5.2796650579866555e-06 0.017240000000000002 -1.9822742096712673e-06 0.017250000000000001 5.0908473509935456e-06 0.017260000000000001 -7.8616341966633566e-06 0.017270000000000001 7.2564231605453959e-06 0.01728 4.0233051721603914e-06 0.01729 -6.1285350321970748e-06 0.017300000000000003 -3.5549335023469691e-06 0.017310000000000002 -1.5628732359383648e-06 0.017320000000000002 -6.157237455689119e-06 0.017330000000000002 4.1655609601705029e-06 0.017340000000000001 -8.2486215802127745e-07 0.017350000000000001 -5.7193060094631412e-06 0.01736 1.5683272667158628e-06 0.01737 4.3577623687372853e-06 0.017380000000000003 3.8426308622509502e-06 0.017390000000000003 6.8065494117874405e-06 0.017400000000000002 2.9058668882565021e-06 0.017410000000000002 3.1578719626554193e-06 0.017420000000000001 -1.6362633038183323e-07 0.017430000000000001 3.2944649462927613e-06 0.017440000000000001 -4.1578346547923095e-06 0.01745 4.4722094362932708e-06 0.01746 3.3232108043141065e-06 0.017470000000000003 6.348187984494225e-07 0.017480000000000002 -2.5604649313977762e-06 0.017490000000000002 -1.0457370787460319e-05 0.017500000000000002 1.9879285729061367e-06 0.017510000000000001 -8.2762277589139186e-06 0.017520000000000001 -2.6448411001868129e-07 0.01753 -2.8110228209019525e-06 0.01754 7.6121285625149208e-07 0.017550000000000003 7.8400642920850863e-06 0.017560000000000003 7.8353065547870741e-06 0.017570000000000002 1.0992614884611302e-05 0.017580000000000002 2.4919692075011422e-06 0.017590000000000001 -6.917774945964298e-06 0.017600000000000001 5.539115589785871e-06 0.017610000000000001 5.8362040341375829e-06 0.01762 -8.842345065135778e-06 0.01763 3.4956655981685221e-06 0.017640000000000003 -9.4242750612260051e-06 0.017650000000000002 4.1754255983626993e-06 0.017660000000000002 1.3042599446675352e-07 0.017670000000000002 -1.2557323286094051e-06 0.017680000000000001 5.636159746882891e-06 0.017690000000000001 -5.8800549870461355e-06 0.0177 -7.1018969497637226e-06 0.01771 5.1469450018627987e-06 0.017720000000000003 -2.4902866359435928e-07 0.017730000000000003 -1.3747793031781545e-06 0.017740000000000002 -2.9265022465142732e-06 0.017750000000000002 -1.9539335783719362e-05 0.017760000000000001 5.7180496423308354e-07 0.017770000000000001 -2.7322699170151989e-06 0.017780000000000001 -6.9884339291155552e-07 0.01779 3.5187718189728763e-06 0.0178 6.4802221894655989e-06 0.017810000000000003 -1.4889736696436308e-06 0.017820000000000003 4.729818451123523e-06 0.017830000000000002 -1.4244796412851869e-06 0.017840000000000002 -2.4884794210906487e-07 0.017850000000000001 -7.2813693097960371e-06 0.017860000000000001 -1.0557846759053354e-06 0.01787 9.4597353239717337e-07 0.01788 -1.5040915555690663e-07 0.017890000000000003 4.0613374687156861e-07 0.017900000000000003 8.1293014613928271e-06 0.017910000000000002 2.1966474295119089e-06 0.017920000000000002 -1.0753570397653303e-05 0.017930000000000001 4.1383264488901165e-06 0.017940000000000001 -3.195839581296915e-06 0.017950000000000001 -3.1687968345166801e-06 0.01796 -3.415869676998581e-06 0.01797 -5.2403459009324364e-06 0.017980000000000003 -4.8244152787111914e-06 0.017990000000000003 9.080155279651514e-06 0.018000000000000002 -2.8581331157562685e-06 0.018010000000000002 8.5022225161859115e-06 0.018020000000000001 -1.5112539408646646e-06 0.018030000000000001 2.3893750416924697e-06 0.01804 7.8381329853971459e-06 0.01805 3.1533288674308151e-06 0.018060000000000003 -4.5193586703432445e-06 0.018070000000000003 -8.1556010579697138e-07 0.018080000000000002 1.034180666399503e-07 0.018090000000000002 7.742584158079686e-06 0.018100000000000002 -1.0480935003956979e-05 0.018110000000000001 -1.0652700079666709e-05 0.018120000000000001 -6.2837187500771182e-06 0.01813 2.5697952484381533e-06 0.01814 -3.2092784583830041e-06 0.018150000000000003 -1.0484492936084876e-07 0.018160000000000003 6.4084677015470954e-06 0.018170000000000002 7.4124397850576365e-06 0.018180000000000002 -6.6720088049409542e-08 0.018190000000000001 9.6879078659147719e-06 0.018200000000000001 -6.0075284287792526e-07 0.01821 -1.2782112536544102e-06 0.01822 -2.8269523572607105e-06 0.018230000000000003 -1.7238473509151832e-06 0.018240000000000003 -2.4348158227243944e-06 0.018250000000000002 2.1509012880585948e-06 0.018260000000000002 -5.2162541017760082e-06 0.018270000000000002 2.8271854708161207e-06 0.018280000000000001 -2.4260335411139701e-06 0.018290000000000001 4.1747161298627458e-06 0.0183 -3.7274991414888897e-06 0.01831 3.357552449894488e-06 0.018320000000000003 -6.3303247592668373e-06 0.018330000000000003 -5.0099763018510053e-06 0.018340000000000002 2.9878074286671039e-07 0.018350000000000002 2.6577664212171151e-06 0.018360000000000001 1.3043674332813095e-06 0.018370000000000001 -1.9190645405302796e-06 0.018380000000000001 6.2346716756764207e-06 0.01839 4.9137705920360488e-07 0.018400000000000003 7.133960542185878e-06 0.018410000000000003 -2.3314599699568084e-06 0.018420000000000002 6.6727518774418974e-07 0.018430000000000002 -1.5620559296322294e-07 0.018440000000000002 -7.1041148719626512e-07 0.018450000000000001 -4.0836471257709305e-07 0.018460000000000001 -8.3812295901352876e-06 0.01847 4.9339694479620375e-06 0.01848 -4.399738516185191e-06 0.018490000000000003 -2.5138989026311571e-06 0.018500000000000003 -8.0527280144977227e-06 0.018510000000000002 4.6794006513812976e-08 0.018520000000000002 -1.8364780107699082e-06 0.018530000000000001 2.3500420911447048e-06 0.018540000000000001 5.4939675576384979e-06 0.018550000000000001 3.0452464042675005e-06 0.01856 8.5395468755047877e-08 0.018570000000000003 -6.335223051762127e-06 0.018580000000000003 3.6849648775332431e-06 0.018590000000000002 2.8365367644535401e-07 0.018600000000000002 2.9934179129101337e-06 0.018610000000000002 -7.0710315788871922e-06 0.018620000000000001 5.7621942650583507e-06 0.018630000000000001 -2.2235041300223112e-06 0.01864 -1.0395116945460921e-06 0.01865 3.5131144147125939e-06 0.018660000000000003 -2.7226351315992593e-06 0.018670000000000003 -1.5895619533771494e-06 0.018680000000000002 5.1796692068632105e-06 0.018690000000000002 4.341384425653963e-06 0.018700000000000001 1.4780392046717331e-06 0.018710000000000001 8.1451691793610604e-07 0.018720000000000001 -1.7480585459303756e-06 0.01873 -9.2608735633441635e-06 0.018740000000000003 4.1000053377437575e-06 0.018750000000000003 -8.2147710580548593e-06 0.018760000000000002 -6.2856832133566049e-06 0.018770000000000002 3.3358137864641009e-06 0.018780000000000002 5.1290127637836852e-06 0.018790000000000001 -7.6359040993326347e-06 0.018800000000000001 7.3438130815122121e-06 0.01881 -5.1611543047776576e-06 0.01882 5.040840132881101e-07 0.018830000000000003 4.3767464240795946e-06 0.018840000000000003 7.9530724341963328e-06 0.018850000000000002 -6.1507294064899581e-06 0.018860000000000002 -5.8713826535825349e-06 0.018870000000000001 2.0888911050960699e-06 0.018880000000000001 -8.7074678184890133e-06 0.018890000000000001 -4.4561108108303689e-06 0.0189 -3.17113876412672e-06 0.018910000000000003 6.1737413769683975e-06 0.018920000000000003 1.0837748065776759e-05 0.018930000000000002 -8.8998931166610043e-06 0.018940000000000002 2.3322558450799988e-06 0.018950000000000002 -2.4918838118997697e-06 0.018960000000000001 -3.5105106004489311e-07 0.018970000000000001 -1.2525896971425642e-05 0.01898 -4.5298634726658188e-06 0.01899 5.1555088213517564e-06 0.019000000000000003 -1.7062665976049401e-06 0.019010000000000003 5.5466137130655549e-06 0.019020000000000002 -1.3520804671848131e-05 0.019030000000000002 -2.3446308006915604e-06 0.019040000000000001 -7.6395256268049133e-06 0.019050000000000001 2.6926376477073231e-06 0.019060000000000001 -1.6142935403379352e-06 0.01907 -1.4534985728091494e-06 0.019080000000000003 -2.2751401130947362e-06 0.019090000000000003 3.9947956369034599e-06 0.019100000000000002 9.0878010851156389e-07 0.019110000000000002 -1.3565423272457043e-06 0.019120000000000002 -7.9147111783212856e-07 0.019130000000000001 -5.7868456439878538e-06 0.019140000000000001 1.2014208478626357e-06 0.01915 -7.0957136769103221e-06 0.01916 -5.2234834899143447e-06 0.019170000000000003 -7.1258868007214978e-06 0.019180000000000003 -1.5420176215071352e-06 0.019190000000000002 -1.3378130815835361e-06 0.019200000000000002 3.8031863209696001e-06 0.019210000000000001 6.8771297613918472e-06 0.019220000000000001 3.1162507113813729e-06 0.019230000000000001 -6.4074462108251767e-08 0.01924 -8.0837474391229663e-06 0.019250000000000003 -2.7220924617528694e-06 0.019260000000000003 -6.1793238332868096e-07 0.019270000000000002 4.3352381191590672e-06 0.019280000000000002 7.8535613518277695e-06 0.019290000000000002 -3.938248850628173e-06 0.019300000000000001 1.1633570606673434e-06 0.019310000000000001 -4.3011412757828322e-06 0.01932 -4.9827797149911953e-06 0.01933 6.1986164726293674e-06 0.019340000000000003 8.6087513572198939e-07 0.019350000000000003 -2.4839801436795533e-06 0.019360000000000002 -7.6323839535555703e-06 0.019370000000000002 -5.6840252060064174e-06 0.019380000000000001 1.5807183037928889e-06 0.019390000000000001 -1.2084181187769969e-06 0.019400000000000001 1.7608783009731293e-06 0.01941 -2.685413987746758e-06 0.019420000000000003 2.3096402000901324e-06 0.019430000000000003 5.8093205003810899e-07 0.019440000000000002 3.993210725519819e-06 0.019450000000000002 2.8754411919760624e-06 0.019460000000000002 1.6995752371809485e-06 0.019470000000000001 1.1263717527456621e-06 0.019480000000000001 1.4217964878544158e-06 0.01949 4.50176121364288e-07 0.0195 -4.2086397225146103e-06 0.019510000000000003 -1.825681435983871e-06 0.019520000000000003 -6.8370540161634877e-06 0.019530000000000002 -7.2658519524900547e-06 0.019540000000000002 -2.5550348656524388e-06 0.019550000000000001 -7.3020062342302567e-06 0.019560000000000001 -1.8171445013316527e-06 0.019570000000000001 -1.0686481563718576e-06 0.01958 -2.6900312785643889e-06 0.019590000000000003 -1.0854014709787437e-06 0.019600000000000003 4.2215033213919736e-06 0.019610000000000002 8.6311167111900551e-06 0.019620000000000002 1.0148451489544617e-05 0.019630000000000002 -4.4803516389956393e-07 0.019640000000000001 -1.2320070485327094e-06 0.019650000000000001 -1.3615941590467544e-06 0.01966 5.9517829583842164e-06 0.01967 1.3299839033585803e-06 0.019680000000000003 -4.9542599392037146e-06 0.019690000000000003 -3.704882445377781e-06 0.019700000000000002 -2.5108714438086745e-06 0.019710000000000002 -5.0929041501384255e-06 0.019720000000000001 -6.5838520554565279e-06 0.019730000000000001 6.8592693348153696e-06 0.019740000000000001 -5.7885150023845387e-07 0.01975 -6.4369215143092408e-06 0.019760000000000003 1.1793675851681988e-07 0.019770000000000003 -1.8439686223351635e-06 0.019780000000000002 -7.0948864901116469e-07 0.019790000000000002 -9.0560050257116202e-07 0.019800000000000002 6.5319595185977514e-06 0.019810000000000001 -7.0824535727969302e-06 0.019820000000000001 2.1512798716391948e-06 0.01983 -1.4911398350282157e-06 0.01984 -7.3948095712300152e-06 0.019850000000000003 -3.3293829279813972e-06 0.019860000000000003 -2.3770782100554616e-06 0.019870000000000002 -4.8398364515987659e-06 0.019880000000000002 4.5007460709633759e-06 0.019890000000000001 -4.0083675803574642e-06 0.019900000000000001 8.7716276715751575e-06 0.019910000000000001 -1.4635367924838687e-06 0.01992 1.0444775976886195e-05 0.019930000000000003 -5.1480508258640927e-06 0.019940000000000003 2.688116049020141e-06 0.019950000000000002 -6.3764933474353972e-08 0.019960000000000002 -1.4925393399873452e-06 0.019970000000000002 -1.9296258650792614e-06 0.019980000000000001 1.8761082577016157e-06 0.019990000000000001 3.2935988776101129e-06 0.02 4.2109608674108482e-07 0.02001 1.9630717548778863e-06 0.020020000000000003 3.5152088913825976e-06 0.020030000000000003 2.564447490691973e-06 0.020040000000000002 -4.8331129091114302e-06 0.020050000000000002 4.3231786845222192e-06 0.020060000000000001 -5.032914209815054e-06 0.020070000000000001 -7.3568004307661401e-06 0.020080000000000001 5.8502742721370444e-06 0.02009 1.2357838524179747e-06 0.020100000000000003 -6.7737551165685765e-06 0.020110000000000003 -4.7418205066463587e-06 0.020120000000000002 -4.3596742443950504e-06 0.020130000000000002 1.6297168467194604e-06 0.020140000000000002 -6.245504532816381e-06 0.020150000000000001 -3.4095744089136452e-06 0.020160000000000001 -9.8109058887665162e-06 0.02017 5.8537932724499099e-06 0.02018 6.1849792920005192e-07 0.020190000000000003 -6.7142066813446526e-06 0.020200000000000003 8.8021703408601676e-06 0.020210000000000002 2.8249382554858575e-06 0.020220000000000002 2.5082432026957805e-07 0.020230000000000001 9.6004344519227888e-07 0.020240000000000001 5.6808791596919645e-06 0.020250000000000001 1.9021690972063268e-07 0.02026 1.1453903985875319e-06 0.020270000000000003 -6.2194284909893928e-06 0.020280000000000003 -4.0422803344995701e-06 0.020290000000000002 4.907024356513975e-06 0.020300000000000002 -3.8595266117858782e-06 0.020310000000000002 1.643094633537585e-06 0.020320000000000001 1.2008874351477158e-06 0.020330000000000001 2.1770850688128479e-06 0.02034 -7.3381508423536361e-07 0.02035 1.8105065996537883e-06 0.020360000000000003 3.4101960022893144e-06 0.020370000000000003 3.8478184121657357e-06 0.020380000000000002 5.0229114662684981e-07 0.020390000000000002 4.1745118665146547e-06 0.020400000000000001 -1.1764525229203748e-06 0.020410000000000001 6.9171021425655348e-06 0.020420000000000001 7.941213207774053e-06 0.02043 -3.7501698910453072e-06 0.020440000000000003 1.5595416461324231e-07 0.020450000000000003 1.0298150568404738e-06 0.020460000000000002 3.5453076831308554e-06 0.020470000000000002 -4.1782175571956944e-06 0.020480000000000002 -3.9268439637818442e-06 0.020490000000000001 4.9874299592895767e-06 0.020500000000000001 -3.720278981014943e-06 0.02051 -6.8908092446599837e-06 0.02052 -3.6306484493814493e-06 0.020530000000000003 1.5816359206950948e-06 0.020540000000000003 2.9933270047596174e-06 0.020550000000000002 4.4675542948543096e-06 0.020560000000000002 -1.6063859059547842e-06 0.020570000000000001 4.6161362874595327e-07 0.020580000000000001 -4.7898602170179839e-06 0.020590000000000001 3.7418593397620685e-06 0.0206 7.2538942281054945e-06 0.020610000000000003 -3.166777636610779e-06 0.020620000000000003 -7.2842814048273299e-06 0.020630000000000003 -5.4489680219573579e-06 0.020640000000000002 1.0707171131676561e-05 0.020650000000000002 6.0313697074176905e-06 0.020660000000000001 1.0723388725996841e-06 0.020670000000000001 -2.4013690296288146e-06 0.02068 3.3196808356797026e-06 0.02069 -7.1387691765175449e-06 0.020700000000000003 2.5652564121988419e-06 0.020710000000000003 1.1318737102005415e-05 0.020720000000000002 2.7533018789532172e-06 0.020730000000000002 2.4301997281928346e-06 0.020740000000000001 -7.7076366334613684e-07 0.020750000000000001 4.2577611732693215e-07 0.020760000000000001 1.3327153361622469e-06 0.02077 9.2254947349580042e-07 0.020780000000000003 -3.3190975661353214e-07 0.020790000000000003 -5.1175506572221547e-06 0.020800000000000003 1.1020337285337266e-06 0.020810000000000002 -5.596361134013285e-06 0.020820000000000002 7.1682462829388278e-06 0.020830000000000001 -3.0626796696784524e-07 0.020840000000000001 -5.9928139143819516e-06 0.02085 -4.4022767997865849e-06 0.02086 -5.7230161977545936e-07 0.020870000000000003 2.3680547966404134e-06 0.020880000000000003 3.4045396326470616e-06 0.020890000000000002 -4.2511229707749385e-06 0.020900000000000002 3.5712156007773451e-06 0.020910000000000002 3.7266637602503416e-07 0.020920000000000001 2.9073007153395893e-06 0.020930000000000001 -2.4207770500481633e-06 0.02094 -4.7612978567009192e-06 0.020950000000000003 2.5009106921089893e-06 0.020960000000000003 6.4726960183437468e-06 0.020970000000000003 -9.1573956770342084e-06 0.020980000000000002 4.0383725291984182e-06 0.020990000000000002 1.1528853771312268e-05 0.021000000000000001 -1.1959139102038979e-06 0.021010000000000001 -3.6883030714034813e-06 0.02102 5.0262842554073858e-08 0.02103 3.7226903686358661e-06 0.021040000000000003 -2.2716480708960144e-06 0.021050000000000003 -2.0846473228080536e-06 0.021060000000000002 -7.6232598228719345e-06 0.021070000000000002 3.2412510107783519e-06 0.021080000000000002 5.9771525399263576e-06 0.021090000000000001 -1.5197859263520883e-06 0.021100000000000001 -8.4316546603785477e-07 0.02111 1.0699853283232551e-06 0.021120000000000003 -4.0048763425941397e-06 0.021130000000000003 6.7798911068650712e-06 0.021140000000000003 8.8475146713715696e-06 0.021150000000000002 1.2052095604649259e-06 0.021160000000000002 3.9028043134856497e-06 0.021170000000000001 1.2585051779670831e-06 0.021180000000000001 2.7952340008249394e-06 0.021190000000000001 -8.9397400856864677e-07 0.0212 -8.6791110870814807e-07 0.021210000000000003 -4.1014953148169965e-06 0.021220000000000003 9.3788098064705375e-07 0.021230000000000002 -7.1459984225390529e-06 0.021240000000000002 3.3405383989602887e-06 0.021250000000000002 -4.1586526999288071e-07 0.021260000000000001 1.0351157350116682e-09 0.021270000000000001 -8.992425834652987e-06 0.02128 -7.3008789424619352e-06 0.021290000000000003 -7.8978855495254063e-06 0.021300000000000003 5.9534709909283369e-06 0.021310000000000003 1.0113014755685206e-06 0.021320000000000002 3.2963298624705313e-06 0.021330000000000002 -4.4105331655358876e-06 0.021340000000000001 -3.2895200148042745e-07 0.021350000000000001 -2.3603131882881768e-06 0.021360000000000001 8.7524565282662152e-06 0.02137 -1.3497232966222096e-06 0.021380000000000003 2.746434156697806e-06 0.021390000000000003 -2.8988730721571789e-06 0.021400000000000002 4.7993314253953595e-07 0.021410000000000002 3.8430153018130608e-06 0.021420000000000002 5.5163993413552908e-06 0.021430000000000001 5.2827452798768907e-06 0.021440000000000001 -7.1519476812585218e-06 0.02145 -3.5327629152743152e-07 0.021460000000000003 1.8188293396691898e-06 0.021470000000000003 -4.1563129347246789e-07 0.021480000000000003 1.3636150265863861e-06 0.021490000000000002 -1.8286931019904647e-06 0.021500000000000002 6.9796358267557554e-07 0.021510000000000001 -2.3961674184919769e-06 0.021520000000000001 -3.3069539478474965e-06 0.021530000000000001 -1.6037900069371462e-06 0.02154 -1.1621182272179927e-05 0.021550000000000003 5.2677622839222881e-07 0.021560000000000003 5.5266886200260875e-06 0.021570000000000002 -4.6063561035012929e-06 0.021580000000000002 -1.064363130195343e-06 0.021590000000000002 -5.467401487384494e-06 0.021600000000000001 1.7906025532562826e-06 0.021610000000000001 -7.2570435636475295e-07 0.02162 -3.2268812050084439e-06 0.021630000000000003 7.4120882673798668e-06 0.021640000000000003 -5.3109014841223591e-06 0.021650000000000003 -6.7673145818995488e-06 0.021660000000000002 9.8380767458678968e-06 0.021670000000000002 -1.4967699377639739e-06 0.021680000000000001 1.7445207335100789e-06 0.021690000000000001 2.1403803070055812e-06 0.021700000000000001 -2.8975158957531541e-06 0.02171 -1.7958932202105137e-06 0.021720000000000003 -7.1469665963301767e-06 0.021730000000000003 -1.4089606481405401e-06 0.021740000000000002 7.5480790829933468e-06 0.021750000000000002 -1.4465144840972115e-06 0.021760000000000002 -3.2436925047659824e-06 0.021770000000000001 -8.9072249934264705e-06 0.021780000000000001 -4.9275293083906032e-06 0.02179 3.4689774270135946e-06 0.021800000000000003 1.0098172015429557e-05 0.021810000000000003 5.7584249163856456e-06 0.021820000000000003 3.497714241296508e-06 0.021830000000000002 6.9244621821149523e-06 0.021840000000000002 5.4557172927540573e-06 0.021850000000000001 2.7827826574675071e-06 0.021860000000000001 7.4537323300622532e-06 0.021870000000000001 5.0422253052780388e-08 0.02188 -1.3075069200170356e-06 0.021890000000000003 -2.5841675221070801e-06 0.021900000000000003 4.8403078295714181e-06 0.021910000000000002 -3.1513205583034852e-06 0.021920000000000002 -1.8678619564757225e-06 0.021930000000000002 5.7792549806363314e-06 0.021940000000000001 -5.331585853632439e-06 0.021950000000000001 2.7278660464174717e-06 0.02196 6.8639110270355982e-06 0.021970000000000003 -6.6038920348785749e-06 0.021980000000000003 -4.3889289509622878e-08 0.021990000000000003 1.5359059475546737e-06 0.022000000000000002 2.4407321381319289e-06 0.022010000000000002 3.5644792341704037e-06 0.022020000000000001 3.5632943891266815e-06 0.022030000000000001 -3.8611681957848213e-06 0.022040000000000001 1.2934158291645087e-06 0.02205 1.6817004620383807e-06 0.022060000000000003 -1.0403184979835228e-05 0.022070000000000003 1.825717991936895e-06 0.022080000000000002 -4.7659817355572737e-07 0.022090000000000002 4.4217518647603404e-06 0.022100000000000002 1.0208178627756153e-05 0.022110000000000001 -2.9171435224998813e-06 0.022120000000000001 -9.2898209704957362e-06 0.02213 3.2467549305670179e-07 0.022140000000000003 2.5043921638660524e-06 0.022150000000000003 3.3695800957226774e-08 0.022160000000000003 2.924776888259364e-06 0.022170000000000002 -3.3464585126386268e-06 0.022180000000000002 -5.6929185085426575e-06 0.022190000000000001 1.4552818812821239e-06 0.022200000000000001 -1.1431538261349117e-06 0.022210000000000001 6.6757596414380051e-06 0.02222 -4.8149302430043461e-06 0.022230000000000003 -8.0287064007268434e-06 0.022240000000000003 -1.645393447123288e-06 0.022250000000000002 -6.2643775375016339e-06 0.022260000000000002 7.2009454142967175e-07 0.022270000000000002 -2.9277520029479654e-07 0.022280000000000001 -4.4969792994550243e-06 0.022290000000000001 2.9358758681941491e-06 0.0223 -4.9827908384531889e-06 0.022310000000000003 3.0353323473361896e-06 0.022320000000000003 -8.8897950338991027e-06 0.022330000000000003 -4.4219407630566806e-06 0.022340000000000002 8.5275233898519408e-06 0.022350000000000002 6.6091982663471628e-06 0.022360000000000001 -5.3649433246383106e-06 0.022370000000000001 3.6371551962160249e-06 0.022380000000000001 -5.2334796788526311e-06 0.02239 -5.1396222914630631e-06 0.022400000000000003 2.3642610843595734e-06 0.022410000000000003 -3.0577768815813861e-06 0.022420000000000002 -2.1997998308459779e-07 0.022430000000000002 -7.5710660565721758e-06 0.022440000000000002 -1.7271297216159857e-06 0.022450000000000001 6.299959689213317e-07 0.022460000000000001 -2.295776570036151e-08 0.02247 -6.6266583830507143e-06 0.022480000000000003 8.2606601867100861e-06 0.022490000000000003 -8.4841925657621203e-07 0.022500000000000003 -5.1492334118866224e-06 0.022510000000000002 1.1864348492805794e-05 0.022520000000000002 -9.9363078049451583e-06 0.022530000000000001 -4.4918582296089584e-06 0.022540000000000001 -1.6367773066713452e-06 0.022550000000000001 2.8373963564045201e-07 0.02256 7.9388559780098481e-06 0.022570000000000003 1.6827408213142288e-06 0.022580000000000003 -5.833306742784847e-06 0.022590000000000002 1.7664338187206805e-07 0.022600000000000002 1.1523595222811057e-05 0.022610000000000002 1.120773818348528e-05 0.022620000000000001 6.6460909028117041e-06 0.022630000000000001 -5.622556497316589e-06 0.02264 4.6039538627632301e-06 0.022650000000000003 -2.070062736592238e-06 0.022660000000000003 3.7091237792091656e-06 0.022670000000000003 5.7164668851621105e-06 0.022680000000000002 5.9950628979530061e-07 0.022690000000000002 6.3132080398008855e-07 0.022700000000000001 1.9087958685883606e-06 0.022710000000000001 6.8315755248820803e-06 0.022720000000000001 4.7480481686760978e-06 0.02273 -9.0595143374412263e-06 0.022740000000000003 -1.094263493404835e-06 0.022750000000000003 -2.2825863933445256e-06 0.022760000000000002 3.5127803718159753e-06 0.022770000000000002 6.5245340699634921e-06 0.022780000000000002 -4.5167401592678174e-06 0.022790000000000001 3.603460637320171e-06 0.022800000000000001 5.1735593322127206e-06 0.02281 -5.8114081622716525e-06 0.022820000000000003 3.378949331227025e-06 0.022830000000000003 2.673340916758228e-06 0.022840000000000003 8.1652014217775478e-07 0.022850000000000002 1.5903700984330723e-06 0.022860000000000002 1.0562966235505344e-06 0.022870000000000001 -6.0515698748356687e-06 0.022880000000000001 -1.3916147338910851e-06 0.022890000000000001 -1.6361409365523118e-06 0.0229 -9.2366905465809183e-06 0.022910000000000003 -1.7025002011648506e-06 0.022920000000000003 6.578650834352328e-06 0.022930000000000002 3.7825700517839348e-06 0.022940000000000002 -3.9096036477573068e-06 0.022950000000000002 -3.8788145727852791e-06 0.022960000000000001 -2.649149828295125e-06 0.022970000000000001 3.551542227844376e-06 0.02298 -1.1943553113241677e-07 0.022990000000000003 -5.6136890992707154e-07 0.023000000000000003 -2.4779674484702308e-07 0.023010000000000003 -5.8486478318766177e-08 0.023020000000000002 -1.0428781451137759e-05 0.023030000000000002 -3.0759988054270318e-07 0.023040000000000001 -2.1784603095458703e-06 0.023050000000000001 -3.3206227077266619e-06 0.023060000000000001 -2.3048910576542531e-06 0.02307 5.6860565700153096e-06 0.023080000000000003 8.275635693528246e-06 0.023090000000000003 -1.3901313993053462e-06 0.023100000000000002 3.3018035488043802e-06 0.023110000000000002 -6.9873188773067011e-06 0.023120000000000002 9.6364942866847641e-07 0.023130000000000001 -1.012676040168809e-06 0.023140000000000001 4.8395269712936863e-06 0.02315 2.5712095628648526e-06 0.023160000000000004 5.3603317674663656e-07 0.023170000000000003 -2.7229218840812139e-06 0.023180000000000003 -8.6029599338865469e-06 0.023190000000000002 1.4098211662933876e-06 0.023200000000000002 -1.0845753915095604e-06 0.023210000000000001 -4.1145870283433551e-07 0.023220000000000001 -5.7152734891034888e-06 0.023230000000000001 -1.0680335478313186e-05 0.02324 2.0899853417948908e-06 0.023250000000000003 -4.6200377566596769e-06 0.023260000000000003 -6.4704365900644252e-06 0.023270000000000002 -1.6481536997952258e-07 0.023280000000000002 -3.3074806355535295e-06 0.023290000000000002 -3.0695711424808927e-06 0.023300000000000001 3.9514938852703229e-06 0.023310000000000001 -5.8968985866721647e-06 0.02332 -2.2463511744330053e-06 0.023330000000000004 -7.6980463935716607e-06 0.023340000000000003 -7.0031746522846286e-06 0.023350000000000003 5.0668518096587415e-06 0.023360000000000002 -6.2856097219608052e-06 0.023370000000000002 1.6375575920131198e-06 0.023380000000000001 6.2288693545794713e-07 0.023390000000000001 1.2112387821951789e-06 0.023400000000000001 5.700687475865333e-06 0.02341 -1.1405119932405995e-05 0.023420000000000003 -6.7327715677699858e-07 0.023430000000000003 3.6247054412478117e-06 0.023440000000000003 9.5137032185622305e-06 0.023450000000000002 -6.3225583754464852e-06 0.023460000000000002 4.8381025827123714e-06 0.023470000000000001 -3.8497345070586304e-06 0.023480000000000001 6.403112906446298e-06 0.02349 -9.4793526587705019e-07 0.023500000000000004 1.3212124494206974e-06 0.023510000000000003 3.880002036514716e-06 0.023520000000000003 -4.6008610057060877e-06 0.023530000000000002 2.0826319272249089e-06 0.023540000000000002 3.384173441098406e-06 0.023550000000000001 -4.8479809343647488e-07 0.023560000000000001 -4.958712431788007e-06 0.023570000000000001 2.0560457611988234e-07 0.02358 1.4014559910288908e-06 0.023590000000000003 -2.7236463553696729e-06 0.023600000000000003 2.0205473262705261e-06 0.023610000000000003 4.2059419277069786e-07 0.023620000000000002 1.0521319641846119e-06 0.023630000000000002 -1.3291430058784604e-06 0.023640000000000001 -1.3323146982416491e-06 0.023650000000000001 -5.9624127514335683e-06 0.02366 -8.2269510605401437e-06 0.023670000000000004 -4.9032287515468745e-07 0.023680000000000003 -4.838861275233398e-06 0.023690000000000003 -5.4367384254293643e-06 0.023700000000000002 4.0809207878522984e-06 0.023710000000000002 2.2961417461176435e-06 0.023720000000000001 -4.886891021512378e-06 0.023730000000000001 2.869234408542967e-06 0.023740000000000001 -2.0604271486394565e-06 0.02375 -2.1727286551383826e-06 0.023760000000000003 9.1094447165289801e-06 0.023770000000000003 -1.7599783973875775e-06 0.023780000000000003 9.2462951226315628e-06 0.023790000000000002 -1.1624873361400161e-06 0.023800000000000002 -2.749274594704654e-06 0.023810000000000001 -6.5177862213909637e-06 0.023820000000000001 -8.6154258824478087e-06 0.02383 8.0184317788293723e-06 0.023840000000000004 8.2168416026948175e-06 0.023850000000000003 8.8250671074366116e-07 0.023860000000000003 -2.7254073584678021e-07 0.023870000000000002 9.0534817555180881e-07 0.023880000000000002 2.31530943091928e-06 0.023890000000000002 -3.5775883285972381e-06 0.023900000000000001 -2.1884976346895335e-06 0.023910000000000001 -6.7982432971127429e-06 0.02392 2.4288247809698841e-06 0.023930000000000003 -3.3709018285804768e-06 0.023940000000000003 -1.914913721341129e-07 0.023950000000000003 2.4544797182417562e-06 0.023960000000000002 1.1222756429619825e-06 0.023970000000000002 1.2347694582951564e-06 0.023980000000000001 -4.3815870883457337e-06 0.023990000000000001 3.5069614083688365e-06 0.024 -4.2380396848455247e-07)
.control
set numdgt=16
set wr_singlescale
set wr_vecnames
tran 1u 0.024 uic
wrdata wave.txt v(state) v(q) v(residual) v(candidate) v(denominator) v(target) v(stagepeak) v(delta) v(corr_first) v(corpeak) v(innerden)
quit
.endc
.end
