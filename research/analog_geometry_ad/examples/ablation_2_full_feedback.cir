Fast AD centered state behavioral P5
.options reltol=1e-7 abstol=1e-12 vntol=1e-9
.model SW SW(Ron=230.0 Roff=1e12 Vt=0.5 Vh=0.1)
Vreset reset 0 PULSE(1 0 10u 10n 10n 25000.0u 50000.0u)
Vsample sample 0 PULSE(0 1 350u 10n 10n 400u 1200u)
Vupdate update 0 PULSE(0 1 770u 10n 10n 400u 1200u)
Sreset state 0 reset 0 SW
Cstate state 0 9.9999999999999995e-08 IC=0
Rleak state 0 1e12
Ileak state 0 1.1800000000002792e-10
Cnext stored 0 9.9999999999999995e-08 IC=0
Rnext stored 0 1e12
Ssample candidate stored sample 0 SW
Supdate stored_read state update 0 SW
Bstored stored_read 0 V=(v(stored)-(4.8653921855823512e-06))/(0.99999968869590705)
Icharge 0 state PULSE(0 4.9999999999999996e-05 1170.02u 1n 1n 9n 1200u)
Ithermal0 0 state PULSE(0 -3.0350394746776234e-06 1170.02u 1n 1n 9n 48000u)
Ithermal1 0 state PULSE(0 4.0172117531468374e-06 2370.02u 1n 1n 9n 48000u)
Ithermal2 0 state PULSE(0 3.4654927653462065e-06 3570.02u 1n 1n 9n 48000u)
Ithermal3 0 state PULSE(0 -1.6350209571115635e-06 4770.0200000000004u 1n 1n 9n 48000u)
Ithermal4 0 state PULSE(0 2.6835042793747924e-06 5970.0200000000004u 1n 1n 9n 48000u)
Ithermal5 0 state PULSE(0 1.7807002599109098e-06 7170.0200000000004u 1n 1n 9n 48000u)
Ithermal6 0 state PULSE(0 -7.0763259024833751e-06 8370.0200000000004u 1n 1n 9n 48000u)
Ithermal7 0 state PULSE(0 -4.0950033295300134e-06 9570.0200000000004u 1n 1n 9n 48000u)
Ithermal8 0 state PULSE(0 -7.0591043136060899e-06 10770.02u 1n 1n 9n 48000u)
Ithermal9 0 state PULSE(0 2.8679550596140193e-06 11970.02u 1n 1n 9n 48000u)
Ithermal10 0 state PULSE(0 -4.8799677539965208e-06 13170.02u 1n 1n 9n 48000u)
Ithermal11 0 state PULSE(0 5.6610291532630095e-06 14370.02u 1n 1n 9n 48000u)
Ithermal12 0 state PULSE(0 -8.8965739270815401e-06 15570.02u 1n 1n 9n 48000u)
Ithermal13 0 state PULSE(0 1.0129048475962028e-06 16770.02u 1n 1n 9n 48000u)
Ithermal14 0 state PULSE(0 4.1347649327241455e-06 17970.02u 1n 1n 9n 48000u)
Ithermal15 0 state PULSE(0 -7.821770752690065e-06 19170.02u 1n 1n 9n 48000u)
Ithermal16 0 state PULSE(0 -3.908357530580755e-06 20370.02u 1n 1n 9n 48000u)
Ithermal17 0 state PULSE(0 -5.8424444631691402e-07 21570.02u 1n 1n 9n 48000u)
Ithermal18 0 state PULSE(0 -4.1758375426451041e-07 22770.02u 1n 1n 9n 48000u)
Ithermal19 0 state PULSE(0 4.1235803486141134e-06 23970.02u 1n 1n 9n 48000u)
Vreadnoise readnoise 0 PWL(0 4.0099590625086497e-06 1.0000000000000001e-05 6.1969989620806574e-06 2.0000000000000002e-05 6.8941298335541864e-06 3.0000000000000004e-05 -6.551039918068936e-07 4.0000000000000003e-05 4.9078827907051089e-06 5.0000000000000002e-05 4.5326564803504729e-06 6.0000000000000008e-05 -7.2974375037154997e-06 7.0000000000000007e-05 -4.8454309917010056e-07 8.0000000000000007e-05 2.2471119559184674e-06 9.0000000000000006e-05 -5.4989036552572424e-06 0.0001 -2.979457639285873e-06 0.00011 -5.0702931448827338e-06 0.00012000000000000002 1.9873744841228731e-06 0.00013000000000000002 -2.5526611876044403e-07 0.00014000000000000001 -4.6681000161196784e-06 0.00015000000000000001 9.0166446007254932e-06 0.00016000000000000001 -2.4958448479428739e-06 0.00017000000000000001 -4.6782771144988418e-06 0.00018000000000000001 2.3569267822872299e-06 0.00019000000000000001 7.485151668420476e-06 0.00020000000000000001 -1.1167880017024902e-05 0.00021000000000000001 2.8300715640618791e-06 0.00022000000000000001 -6.2190726843940015e-06 0.00023000000000000001 -4.5074976049796536e-06 0.00024000000000000003 -9.4319047121812087e-06 0.00025000000000000001 9.4800397782612978e-06 0.00026000000000000003 2.3067421630538057e-06 0.00027 -1.0145069532327737e-06 0.00028000000000000003 2.040912097545316e-06 0.00029 1.1073002700757624e-07 0.00030000000000000003 -5.1883854893798853e-06 0.00031 8.008279644506194e-06 0.00032000000000000003 5.7281824077270845e-06 0.00033000000000000005 3.9691979498321041e-06 0.00034000000000000002 5.1780128934058282e-06 0.00035000000000000005 -5.4131170591218042e-06 0.00036000000000000002 -1.987740770533947e-06 0.00037000000000000005 -6.2669053678387155e-07 0.00038000000000000002 2.7147434179692419e-06 0.00039000000000000005 -1.4035621135049284e-05 0.00040000000000000002 1.8135386103446856e-06 0.00041000000000000005 -6.0394303459003954e-07 0.00042000000000000002 -8.7636350892260095e-06 0.00043000000000000004 4.2677568173810966e-06 0.00044000000000000002 5.5467128293892477e-07 0.00045000000000000004 -3.0585754337359261e-07 0.00046000000000000001 1.381122055175017e-06 0.00047000000000000004 4.7418961512130512e-06 0.00048000000000000007 -5.6502213177867562e-06 0.00049000000000000009 1.5217189912329954e-06 0.00050000000000000001 2.5699623807526865e-06 0.00051000000000000004 -2.1947845661739724e-06 0.00052000000000000006 3.6344566572836831e-06 0.00053000000000000009 -7.352227994805327e-06 0.00054000000000000001 -3.0102558596354969e-06 0.00055000000000000003 8.9777552508941482e-06 0.00056000000000000006 -3.1307642075361249e-06 0.00057000000000000009 -7.2207664677440337e-06 0.00058 -2.7291722394519334e-06 0.00059000000000000003 2.946168421673533e-06 0.00060000000000000006 -1.6756356862731969e-06 0.00061000000000000008 -7.1690990931362602e-06 0.00062 -4.1410008904317694e-06 0.00063000000000000003 2.0588872889741602e-06 0.00064000000000000005 -8.6960742544156819e-06 0.00065000000000000008 4.9594922629850796e-06 0.0006600000000000001 2.5201185526902491e-07 0.00067000000000000002 9.9516277136441948e-08 0.00068000000000000005 -3.1930527601134005e-06 0.00069000000000000008 -4.8131214152193551e-07 0.0007000000000000001 -4.4316823726053671e-06 0.00071000000000000002 -1.3377364886785443e-07 0.00072000000000000005 -2.7431353247855192e-06 0.00073000000000000007 1.9115711032655469e-06 0.0007400000000000001 3.3795098574940399e-07 0.00075000000000000002 -5.2066909397167397e-06 0.00076000000000000004 2.4395707753145955e-07 0.00077000000000000007 -3.9998439258082568e-06 0.00078000000000000009 -3.1259332162392083e-06 0.00079000000000000001 -4.0618481019206542e-06 0.00080000000000000004 3.8771979364225145e-06 0.00081000000000000006 -1.1439387733636964e-05 0.00082000000000000009 -3.2839361831819294e-07 0.00083000000000000012 3.8047684811056642e-08 0.00084000000000000003 8.8299491568919888e-07 0.00085000000000000006 2.3371394193298061e-07 0.00086000000000000009 4.4754224862146483e-06 0.00087000000000000011 7.3857814967201401e-06 0.00088000000000000003 1.836004514233128e-06 0.00089000000000000006 -9.6592855806212629e-06 0.00090000000000000008 -8.5833750042206481e-06 0.00091000000000000011 -6.2532167705743495e-06 0.00092000000000000003 -9.7988720958803638e-08 0.00093000000000000005 -5.3192397750715639e-06 0.00094000000000000008 6.913899552486103e-06 0.00095000000000000011 4.5517743022382848e-07 0.00096000000000000013 -3.9273917470242824e-06 0.00097000000000000005 -1.3927321757385238e-07 0.00098000000000000019 -5.4548251364891721e-06 0.00098999999999999999 -3.6150239931372462e-06 0.001 -6.2921926525829625e-06 0.00101 2.2110496037998995e-07 0.0010200000000000001 1.1549653309524028e-06 0.0010300000000000001 -9.3924263260696863e-06 0.0010400000000000001 -5.2925209295777465e-06 0.0010500000000000002 1.124454758616938e-05 0.0010600000000000002 7.6707476433830969e-07 0.00107 -5.0724568078695374e-07 0.00108 -7.2218430331611637e-07 0.00109 3.4743875741932749e-06 0.0011000000000000001 -4.9305677340769884e-06 0.0011100000000000001 1.7550940288120141e-06 0.0011200000000000001 5.8003081592325197e-06 0.0011300000000000001 8.0389252592688911e-06 0.0011400000000000002 -2.6245846520551787e-06 0.0011500000000000002 3.7471260011171572e-06 0.00116 -6.7121135180145719e-07 0.00117 -3.3318183887186882e-06 0.0011800000000000001 -3.2046538896431029e-06 0.0011900000000000001 1.3412563185728877e-06 0.0012000000000000001 -1.6683432496472537e-06 0.0012100000000000001 -4.1595146617906598e-06 0.0012200000000000002 6.6202720583620943e-07 0.0012300000000000002 1.1602346716005936e-06 0.00124 1.1726706626851561e-05 0.00125 -1.7961260533363583e-06 0.0012600000000000001 2.6125190515039382e-06 0.0012700000000000001 -5.5883449271683922e-06 0.0012800000000000001 2.0583054548083709e-06 0.0012900000000000001 -1.1348768026206903e-06 0.0013000000000000002 9.0553607272389036e-08 0.0013100000000000002 -5.9491372694888912e-06 0.0013200000000000002 2.6770432717563334e-06 0.00133 4.4709693085208095e-07 0.00134 -4.3388332747976544e-06 0.0013500000000000001 3.8557944546053397e-06 0.0013600000000000001 -1.8221529070748962e-06 0.0013700000000000001 -4.5335248686166619e-06 0.0013800000000000002 7.1384507414861904e-06 0.0013900000000000002 5.3789165205218274e-06 0.0014000000000000002 -4.0953549489454457e-06 0.00141 3.8719181586949263e-06 0.00142 -4.3368706554756097e-06 0.0014300000000000001 -2.8151743802085378e-06 0.0014400000000000001 7.966753516720294e-06 0.0014500000000000001 2.0941412803266504e-06 0.0014600000000000001 -3.0926062661374683e-06 0.0014700000000000002 -1.3651115176694612e-06 0.0014800000000000002 -1.8919664733207446e-07 0.0014900000000000002 -8.9629819790446653e-06 0.0015 5.0025376261666708e-07 0.0015100000000000001 7.1732481407127466e-07 0.0015200000000000001 1.134930098397815e-07 0.0015300000000000001 -3.5181015233425176e-06 0.0015400000000000001 -1.8104793686567226e-06 0.0015500000000000002 -4.1012312909672333e-06 0.0015600000000000002 -8.4920492216972876e-06 0.0015700000000000002 7.0669324396945658e-06 0.00158 -1.1701261319892812e-06 0.0015900000000000001 -2.8162600686265131e-07 0.0016000000000000001 -2.9226394109729323e-06 0.0016100000000000001 4.4212022116870866e-06 0.0016200000000000001 -8.7011904689183035e-06 0.0016300000000000002 -8.8171760093843443e-06 0.0016400000000000002 -3.0372859943128279e-07 0.0016500000000000002 4.4311683959907362e-06 0.0016600000000000002 3.1111982088610012e-06 0.00167 -1.7365537725358795e-06 0.0016800000000000001 -3.3774858588899754e-06 0.0016900000000000001 8.4241464587616657e-06 0.0017000000000000001 -4.6604058879646574e-07 0.0017100000000000001 3.0104724208869529e-06 0.0017200000000000002 -6.8203148254932362e-06 0.0017300000000000002 3.8901145198451704e-06 0.0017400000000000002 4.788263020425344e-06 0.00175 7.3546886406496213e-06 0.0017600000000000001 -2.8067293358895743e-06 0.0017700000000000001 4.2799775310780859e-06 0.0017800000000000001 -2.6338239097810875e-06 0.0017900000000000001 -2.087151857854175e-06 0.0018000000000000002 3.2585789732287483e-06 0.0018100000000000002 -1.4809204011018852e-06 0.0018200000000000002 -6.8968772510335922e-06 0.0018300000000000002 -2.3168367988647815e-06 0.0018400000000000001 -1.3420069543447708e-06 0.0018500000000000001 -3.5498805988970208e-06 0.0018600000000000001 -2.9688708165722687e-06 0.0018700000000000001 6.6164982946076395e-06 0.0018800000000000002 -2.1968250638212775e-06 0.0018900000000000002 7.6880935385433524e-06 0.0019000000000000002 2.8164397344737499e-06 0.0019100000000000002 -6.7730220614321609e-06 0.0019200000000000003 -4.3019945904351188e-06 0.0019300000000000001 -5.7486476911049506e-06 0.0019400000000000001 6.0145072088493975e-06 0.0019500000000000001 -7.5590821823535568e-06 0.0019600000000000004 -5.0282550694361874e-06 0.00197 -7.4324119170741113e-06 0.00198 4.9182245983710049e-06 0.00199 -4.5621877386376798e-06 0.002 2.2360500591499251e-06 0.0020100000000000001 5.0606735907829022e-06 0.0020200000000000001 3.2681048377595943e-06 0.0020300000000000001 -4.0611031816842531e-06 0.0020400000000000001 -4.1879288086043324e-07 0.0020500000000000002 -5.7800901165338866e-06 0.0020600000000000002 -4.3662739781963578e-06 0.0020700000000000002 1.6052747016474448e-06 0.0020800000000000003 -5.1304166519883854e-06 0.0020900000000000003 -1.7586151424148548e-06 0.0021000000000000003 1.035266490688065e-06 0.0021100000000000003 7.1461431425494288e-07 0.0021200000000000004 8.2744049056750787e-06 0.0021300000000000004 -4.8277080786175821e-06 0.00214 -1.1619722383354644e-06 0.00215 1.0360919399018686e-06 0.00216 -7.6843377664892838e-06 0.0021700000000000001 -6.6859963779788659e-06 0.0021800000000000001 1.3806988640810664e-07 0.0021900000000000001 7.8542681896401274e-06 0.0022000000000000001 4.1920308883930742e-06 0.0022100000000000002 -1.620328857024259e-06 0.0022200000000000002 -1.1673698184352073e-07 0.0022300000000000002 4.7951120386585146e-06 0.0022400000000000002 8.832438358772472e-07 0.0022500000000000003 -7.9162062410326023e-07 0.0022600000000000003 7.7909625670965559e-07 0.0022700000000000003 1.5300818749478467e-06 0.0022800000000000003 7.1422739204263189e-06 0.0022900000000000004 -8.0838247067283781e-06 0.0023000000000000004 9.4333669005552051e-07 0.00231 5.0345890932421068e-06 0.00232 -9.2727925419432469e-06 0.00233 4.0063549878715492e-06 0.0023400000000000001 5.0169115766850953e-07 0.0023500000000000001 5.1490433448035444e-06 0.0023600000000000001 -3.9457452255629824e-06 0.0023700000000000001 -2.3147264825423702e-06 0.0023800000000000002 9.7839813030934069e-07 0.0023900000000000002 1.5330954995207356e-06 0.0024000000000000002 7.8329351844567131e-06 0.0024100000000000002 6.0513675316097056e-06 0.0024200000000000003 -7.764173608728141e-06 0.0024300000000000003 2.3885417057763519e-06 0.0024400000000000003 9.801673058853866e-06 0.0024500000000000004 6.5127597852591352e-06 0.0024600000000000004 1.2619321083332856e-06 0.0024700000000000004 -3.8454811894455107e-06 0.00248 1.3859057167512313e-06 0.00249 -3.333748753339817e-06 0.0025000000000000001 1.4071131393742123e-06 0.0025100000000000001 -8.7260714769472611e-06 0.0025200000000000001 4.5708033131026351e-08 0.0025300000000000001 -2.9482930412898397e-06 0.0025400000000000002 6.9950951923060937e-06 0.0025500000000000002 2.7553672824792712e-06 0.0025600000000000002 -4.6720057135472606e-06 0.0025700000000000002 3.8341813136537027e-06 0.0025800000000000003 2.9038089242551283e-06 0.0025900000000000003 5.8429733689711129e-06 0.0026000000000000003 -1.8954218697061039e-06 0.0026100000000000003 4.2734685879202669e-06 0.0026200000000000004 9.3717166933712328e-07 0.0026300000000000004 -7.5977564759369058e-06 0.0026400000000000004 2.8416937744714661e-06 0.00265 -7.0751423283757282e-06 0.00266 -1.1363793419314609e-06 0.0026700000000000001 -4.0747740538187812e-06 0.0026800000000000001 -1.4275807111672438e-06 0.0026900000000000001 -1.1630327095393493e-05 0.0027000000000000001 -2.3920975228719006e-06 0.0027100000000000002 -3.7527217059875764e-06 0.0027200000000000002 -7.7834993454081212e-07 0.0027300000000000002 -1.8647120900905649e-06 0.0027400000000000002 2.9051521610430989e-06 0.0027500000000000003 -1.1056503023057919e-05 0.0027600000000000003 -3.7020314667456282e-06 0.0027700000000000003 -8.5496590739766965e-07 0.0027800000000000004 -6.1841113672825567e-06 0.0027900000000000004 4.345002618841899e-06 0.0028000000000000004 -8.0629008438973214e-06 0.0028100000000000004 -1.350565479384662e-07 0.00282 -7.0869232770435514e-06 0.0028300000000000001 -8.1802656260778617e-06 0.0028400000000000001 -6.8458096530637495e-07 0.0028500000000000001 5.226539086526212e-06 0.0028600000000000001 8.5678421712359954e-06 0.0028700000000000002 4.5857623593705783e-06 0.0028800000000000002 -3.3254870223712688e-06 0.0028900000000000002 5.0487727306884673e-06 0.0029000000000000002 -7.80907133650743e-06 0.0029100000000000003 -3.377502419676254e-06 0.0029200000000000003 -1.0932269145055479e-05 0.0029300000000000003 7.7575104266993411e-06 0.0029400000000000003 2.9428649342488247e-06 0.0029500000000000004 9.4884365691114463e-06 0.0029600000000000004 3.9310419687736146e-06 0.0029700000000000004 2.2705606533248374e-06 0.0029800000000000004 2.0771535439267399e-06 0.00299 -2.815230793057635e-06 0.0030000000000000001 2.7433525580177669e-06 0.0030100000000000001 -6.5363164969098406e-06 0.0030200000000000001 -2.0743872376012381e-06 0.0030300000000000001 9.3378985052453837e-06 0.0030400000000000002 -4.8398409384565646e-07 0.0030500000000000002 -5.4887210334258619e-06 0.0030600000000000002 6.4268171447824672e-07 0.0030700000000000002 -1.7309251154879053e-06 0.0030800000000000003 -3.0999616997344136e-06 0.0030900000000000003 2.9393295346515942e-06 0.0031000000000000003 8.7423763924834435e-06 0.0031100000000000004 9.0793531408509298e-06 0.0031200000000000004 -4.320172111671974e-06 0.0031300000000000004 3.7473908722153918e-06 0.0031400000000000004 -5.7703582308042698e-06 0.0031500000000000005 -8.5052499372697949e-06 0.00316 -2.7347250463341679e-06 0.0031700000000000001 2.066629495702955e-06 0.0031800000000000001 -2.0219485883624743e-06 0.0031900000000000001 -6.314568826442312e-06 0.0032000000000000002 -6.5509945041028264e-06 0.0032100000000000002 -1.1005127759100462e-06 0.0032200000000000002 2.9066540910585293e-07 0.0032300000000000002 -8.8611501108334402e-06 0.0032400000000000003 3.0583450399682883e-06 0.0032500000000000003 5.3687187447928416e-06 0.0032600000000000003 8.8638004314187402e-07 0.0032700000000000003 2.2851889620702497e-06 0.0032800000000000004 -5.1956928286895711e-06 0.0032900000000000004 7.0451361191483916e-06 0.0033000000000000004 -2.1167759929973296e-06 0.0033100000000000004 2.5152306690123157e-06 0.0033200000000000005 1.6629371045458565e-06 0.0033300000000000001 5.5136206412010584e-06 0.0033400000000000001 4.5927770343980481e-07 0.0033500000000000001 3.6263486577704092e-06 0.0033600000000000001 -4.781832482743027e-06 0.0033700000000000002 -3.6957962701833509e-06 0.0033800000000000002 3.0023336051493394e-06 0.0033900000000000002 5.1471317118668075e-06 0.0034000000000000002 -9.9808698620023875e-06 0.0034100000000000003 5.5314195655608051e-06 0.0034200000000000003 -1.2197695858864689e-06 0.0034300000000000003 4.8452554599316934e-06 0.0034400000000000003 2.8232200169485262e-06 0.0034500000000000004 5.6697659497257594e-06 0.0034600000000000004 -4.9267171291919713e-07 0.0034700000000000004 4.6108600782255255e-06 0.0034800000000000005 -9.7599589334341143e-06 0.0034900000000000005 -8.325276507355682e-06 0.0035000000000000001 -8.8973466648613912e-06 0.0035100000000000001 8.080976459006609e-07 0.0035200000000000001 -1.3628608167791641e-06 0.0035300000000000002 2.6492215086442038e-06 0.0035400000000000002 -4.6712848329894621e-06 0.0035500000000000002 8.0074296796995353e-06 0.0035600000000000002 -7.2240627686653906e-06 0.0035700000000000003 -6.9518832466525589e-07 0.0035800000000000003 1.7150554435675878e-06 0.0035900000000000003 6.5328707659238685e-06 0.0036000000000000003 4.2361319399574682e-06 0.0036100000000000004 -1.8729799908523638e-07 0.0036200000000000004 -3.3968818473581421e-08 0.0036300000000000004 -7.8118731391427121e-06 0.0036400000000000004 -2.2546771000403303e-06 0.0036500000000000005 3.443886255411586e-06 0.0036600000000000005 -6.9968278939652482e-06 0.0036700000000000001 1.7872456245736492e-06 0.0036800000000000001 4.8739750241833821e-06 0.0036900000000000001 -1.1098404353815443e-06 0.0037000000000000002 -3.1946568337399935e-06 0.0037100000000000002 3.6454323178595115e-06 0.0037200000000000002 1.4372265368383992e-06 0.0037300000000000002 -4.9653096375286026e-06 0.0037400000000000003 9.7057184997601481e-07 0.0037500000000000003 5.3715877956103068e-07 0.0037600000000000003 5.4301767475320787e-06 0.0037700000000000003 -4.8794175272193603e-06 0.0037800000000000004 -2.7173591429264768e-06 0.0037900000000000004 -4.7425499678885558e-06 0.0038000000000000004 6.8884139089912619e-07 0.0038100000000000005 3.7562655110574592e-06 0.0038200000000000005 2.0599235569146993e-06 0.0038300000000000005 2.4234305167311433e-06 0.0038400000000000005 1.7929480261873711e-06 0.0038500000000000001 2.8943186402660652e-06 0.0038600000000000001 2.5353828430591814e-06 0.0038700000000000002 -5.2572765277694893e-06 0.0038800000000000002 -7.7383285713770284e-06 0.0038900000000000002 -3.9710349143693673e-06 0.0039000000000000003 1.2177737474309252e-06 0.0039100000000000003 1.1628823960019139e-06 0.0039200000000000007 -1.2817228185298588e-05 0.0039300000000000003 2.5699280068704059e-06 0.0039399999999999999 1.6777643640249108e-07 0.0039500000000000004 -8.8516177024040128e-06 0.00396 -4.0424308306618497e-07 0.0039700000000000004 -1.9250024298346913e-06 0.00398 9.201226004010302e-07 0.0039900000000000005 7.5924799334200374e-06 0.0040000000000000001 5.3399209985382171e-06 0.0040100000000000005 3.9140425412081532e-07 0.0040200000000000001 2.5864550594891618e-06 0.0040300000000000006 -8.5058865673237074e-06 0.0040400000000000002 -3.2553849008167025e-06 0.0040500000000000006 7.6200822606745276e-06 0.0040600000000000002 -2.2858022644583571e-07 0.0040700000000000007 1.008281912935394e-05 0.0040800000000000003 1.0704182163753789e-06 0.0040900000000000008 4.7660970164771101e-06 0.0041000000000000003 -7.7611252835210703e-07 0.0041099999999999999 -5.4260320634134643e-07 0.0041200000000000004 7.7895073352796163e-06 0.00413 -5.5872885538192953e-06 0.0041400000000000005 -1.5025668650031196e-06 0.00415 2.7848151481386694e-06 0.0041600000000000005 -3.8721096848814391e-06 0.0041700000000000001 -8.982240974132968e-06 0.0041800000000000006 -2.6976822697997179e-07 0.0041900000000000001 3.0233502492772843e-06 0.0042000000000000006 -2.3232482107217155e-06 0.0042100000000000002 7.2059750800289054e-06 0.0042200000000000007 1.2382582208281766e-06 0.0042300000000000003 6.1771600894358826e-06 0.0042400000000000007 -1.480051178641548e-06 0.0042500000000000003 -2.3922894519228902e-07 0.0042600000000000008 -4.5938251335802544e-06 0.0042700000000000004 2.9576101985840523e-06 0.00428 -4.6670403327756855e-07 0.0042900000000000004 -1.1642344264805732e-06 0.0043 -3.404749581512507e-06 0.0043100000000000005 -1.3123183515363195e-05 0.0043200000000000001 -3.5857904273441475e-06 0.0043300000000000005 -2.0984262888512886e-06 0.0043400000000000001 1.2734780024303897e-06 0.0043500000000000006 2.4052558287792381e-06 0.0043600000000000002 1.1586501565077983e-05 0.0043700000000000006 -5.7986248541188205e-06 0.0043800000000000002 -4.6236212667109342e-06 0.0043900000000000007 4.1491020280825628e-06 0.0044000000000000003 1.6452839026515523e-06 0.0044100000000000007 6.8830584338755158e-06 0.0044200000000000003 2.6871219314183912e-06 0.0044300000000000008 2.4427518665139913e-06 0.0044400000000000004 9.0513358236308465e-06 0.00445 -6.3306943480909337e-06 0.0044600000000000004 9.1058740960267525e-07 0.00447 2.7390430575036273e-06 0.0044800000000000005 -4.7590273142629035e-08 0.0044900000000000001 -3.7443582375614445e-06 0.0045000000000000005 2.8216697987617121e-06 0.0045100000000000001 3.932121568073289e-06 0.0045200000000000006 5.0153335274451457e-06 0.0045300000000000002 -5.3030962465864189e-06 0.0045400000000000006 -1.9344221976281249e-06 0.0045500000000000002 -1.833900415522043e-06 0.0045600000000000007 3.6955319091372511e-06 0.0045700000000000003 5.777164674889315e-06 0.0045800000000000007 2.9246856389319293e-06 0.0045900000000000003 3.6208240131324962e-06 0.0046000000000000008 1.3372206501866507e-06 0.0046100000000000004 -2.5698469204699454e-07 0.00462 3.6198228810424274e-06 0.0046300000000000004 1.1598223997100812e-06 0.00464 3.4152868270661045e-06 0.0046500000000000005 -8.1350660549227206e-06 0.0046600000000000001 -5.5272993468039194e-06 0.0046700000000000005 7.773654610927325e-06 0.0046800000000000001 -1.0825844310202962e-05 0.0046900000000000006 1.5247507738699124e-06 0.0047000000000000002 -4.3212771392628849e-06 0.0047100000000000006 7.5391735795508278e-06 0.0047200000000000002 -5.5166061363513722e-06 0.0047300000000000007 -6.9328682858135055e-07 0.0047400000000000003 8.0787934689759125e-06 0.0047500000000000007 -2.535300024356854e-07 0.0047600000000000003 4.238312130156022e-07 0.0047700000000000008 -1.3448077884751085e-07 0.0047800000000000004 -4.7476562475324064e-07 0.00479 -3.2133189743820841e-06 0.0048000000000000004 -2.5673595484120396e-06 0.00481 5.3074764298246132e-06 0.0048200000000000005 -1.7522423787714864e-05 0.0048300000000000001 7.3072638330806672e-08 0.0048400000000000006 5.6081053900820936e-06 0.0048500000000000001 -6.9198223243406524e-06 0.0048600000000000006 -3.1492337519581859e-07 0.0048700000000000002 5.3285132624511949e-06 0.0048800000000000007 4.0306242308895142e-06 0.0048900000000000002 1.8878368767455443e-06 0.0049000000000000007 2.3266224131374436e-07 0.0049100000000000003 -6.3480097939973943e-06 0.0049200000000000008 4.4325156599428845e-06 0.0049300000000000004 3.8623340340675824e-07 0.0049400000000000008 -1.0944082146500713e-05 0.0049500000000000004 4.1047126082624971e-06 0.00496 3.1025977163567402e-07 0.0049700000000000005 1.3506790098292904e-06 0.0049800000000000001 2.6643066003911368e-06 0.0049900000000000005 -9.7223506118669704e-06 0.0050000000000000001 5.0714838443510815e-06 0.0050100000000000006 1.1983525447122467e-05 0.0050200000000000002 5.6777877008227891e-06 0.0050300000000000006 -8.239694244869619e-06 0.0050400000000000002 5.9095158257075284e-06 0.0050500000000000007 -2.1811829873435429e-07 0.0050600000000000003 5.0251667346431517e-06 0.0050700000000000007 -3.6743900336914665e-06 0.0050800000000000003 1.1723725956940845e-05 0.0050900000000000008 1.2672711682775976e-06 0.0051000000000000004 6.0149397937788422e-06 0.0051100000000000008 1.8977709082155671e-06 0.0051200000000000004 8.0486407379380316e-06 0.00513 2.5664767840494142e-06 0.0051400000000000005 3.8616079705174502e-06 0.0051500000000000001 7.9675355780287979e-07 0.0051600000000000005 -3.2252321743011961e-06 0.0051700000000000001 -9.3442052160348331e-06 0.0051800000000000006 4.633859603552777e-06 0.0051900000000000002 -2.8995745588854958e-06 0.0052000000000000006 1.0135731907087805e-06 0.0052100000000000002 -1.3699708875113806e-05 0.0052200000000000007 -3.9302103819523703e-06 0.0052300000000000003 -3.6599365108394948e-06 0.0052400000000000007 -1.2753133096739e-05 0.0052500000000000003 -3.7044173721870356e-07 0.0052600000000000008 2.551318078526155e-06 0.0052700000000000004 4.2015331042929473e-06 0.0052800000000000008 4.7763115676893777e-06 0.0052900000000000004 4.900018152340976e-06 0.0053 7.098044822853737e-06 0.0053100000000000005 -5.9979055456025495e-06 0.0053200000000000001 3.1347683439134014e-06 0.0053300000000000005 4.6327809053149603e-06 0.0053400000000000001 -2.5137395872083408e-06 0.0053500000000000006 2.2286145099146522e-06 0.0053600000000000002 5.1235652281353279e-06 0.0053700000000000006 2.2803168966266565e-06 0.0053800000000000002 -1.0608736631741457e-05 0.0053900000000000007 -4.3801526328945432e-06 0.0054000000000000003 2.1765000172133799e-07 0.0054100000000000007 2.0630763421177483e-07 0.0054200000000000003 3.2838173972879977e-06 0.0054300000000000008 4.2225536415182875e-06 0.0054400000000000004 -4.1288398844211384e-06 0.0054500000000000009 -1.3750172533526884e-06 0.0054600000000000004 -5.687371616875054e-06 0.00547 -8.7079214556039748e-06 0.0054800000000000005 6.3416907837165745e-06 0.0054900000000000001 7.8934905292135073e-07 0.0055000000000000005 1.7691065051959483e-06 0.0055100000000000001 -7.429520117522848e-07 0.0055200000000000006 3.6660947059805928e-06 0.0055300000000000002 -4.4150362432332139e-06 0.0055400000000000007 -8.9330699192233115e-07 0.0055500000000000002 -4.7063069660180988e-06 0.0055600000000000007 -4.0073061311727795e-06 0.0055700000000000003 -3.9203364019197547e-06 0.0055800000000000008 -5.913753181755364e-06 0.0055900000000000004 -1.0391107773565543e-05 0.0056000000000000008 1.0030703625041132e-06 0.0056100000000000004 4.9326747097589659e-06 0.0056200000000000009 -3.3946451769768971e-06 0.0056300000000000005 -2.4811447549382959e-06 0.00564 1.1148652925777319e-05 0.0056500000000000005 -1.1313382059630338e-05 0.0056600000000000001 -1.558872080206161e-06 0.0056700000000000006 4.6344650046747409e-07 0.0056800000000000002 -1.1234222183998549e-06 0.0056900000000000006 -6.989791569337417e-06 0.0057000000000000002 -1.9009746427625361e-06 0.0057100000000000007 4.2271207685734347e-07 0.0057200000000000003 -8.7683146700524047e-06 0.0057300000000000007 -1.849220280495356e-06 0.0057400000000000003 1.0225870083663314e-05 0.0057500000000000008 9.123629437744321e-06 0.0057600000000000004 -1.0777661855854863e-05 0.0057700000000000008 1.5932060964653937e-06 0.0057800000000000004 8.2686081061509172e-07 0.0057900000000000009 -7.8928367712939159e-06 0.0058000000000000005 6.9239702679149926e-08 0.0058100000000000001 3.8634544993659375e-06 0.0058200000000000005 -1.8549158125295974e-06 0.0058300000000000001 7.3373257780289647e-07 0.0058400000000000006 -3.9605123896521683e-06 0.0058500000000000002 -4.6719234620672077e-06 0.0058600000000000006 2.0729384201003312e-06 0.0058700000000000002 -4.9891749198233598e-06 0.0058800000000000007 -8.6227215363172117e-07 0.0058900000000000003 -2.9175344370640474e-06 0.0059000000000000007 -4.5535342240002458e-06 0.0059100000000000003 -9.2293791609212871e-06 0.0059200000000000008 -8.056175567740526e-07 0.0059300000000000004 6.176077826895406e-06 0.0059400000000000008 -3.6335475692949531e-06 0.0059500000000000004 5.8479947435259779e-07 0.0059600000000000009 4.5047467010481616e-06 0.0059700000000000005 4.2887328113928198e-06 0.0059800000000000001 -2.1785033988088303e-06 0.0059900000000000005 5.8423623031325127e-06 0.0060000000000000001 -2.0980188881682758e-06 0.0060100000000000006 -1.7632634764969546e-06 0.0060200000000000002 -1.2210673950540874e-05 0.0060300000000000006 -6.1431607165450684e-06 0.0060400000000000002 -3.4246629441183615e-08 0.0060500000000000007 6.3994152303101179e-06 0.0060600000000000003 2.9866769603401718e-06 0.0060700000000000007 4.8915096274209694e-06 0.0060800000000000003 4.1658284021337722e-06 0.0060900000000000008 -4.6316104728411297e-06 0.0061000000000000004 -1.3120107632904534e-06 0.0061100000000000008 1.2328148475535887e-05 0.0061200000000000004 7.6579624040235373e-07 0.0061300000000000009 1.6452745581914866e-06 0.0061400000000000005 3.4761685644200523e-06 0.0061500000000000001 6.8800685874783365e-07 0.0061600000000000005 5.4660594672579966e-06 0.0061700000000000001 1.9394848811755522e-06 0.0061800000000000006 6.4650878217090487e-06 0.0061900000000000002 -3.2763897447533246e-06 0.0062000000000000006 -2.4547992729971586e-06 0.0062100000000000002 -1.738604481861283e-06 0.0062200000000000007 1.4864949333995874e-06 0.0062300000000000003 -9.844841333501452e-06 0.0062400000000000008 -2.6110589536685799e-07 0.0062500000000000003 2.870286586133855e-06 0.0062600000000000008 -6.6029108355503626e-06 0.0062700000000000004 -3.9304782930882758e-07 0.0062800000000000009 7.5595230762548126e-06 0.0062900000000000005 -1.3585932429349419e-06 0.0063000000000000009 -2.8022558257081454e-06 0.0063100000000000005 7.3430956930731519e-06 0.0063200000000000001 -3.9809421934677557e-06 0.0063300000000000006 3.1567900158809146e-06 0.0063400000000000001 2.6671500230157029e-06 0.0063500000000000006 2.4597959176860353e-06 0.0063600000000000002 5.2946617180311299e-06 0.0063700000000000007 -3.1222740142870206e-06 0.0063800000000000003 -1.0297799501730865e-05 0.0063900000000000007 3.6941369103869528e-06 0.0064000000000000003 -2.1440918503849979e-06 0.0064100000000000008 9.5561210251062933e-09 0.0064200000000000004 2.0991123881325869e-06 0.0064300000000000008 -6.2246073098811834e-06 0.0064400000000000004 -5.7009609690036383e-06 0.0064500000000000009 6.9641756773615475e-06 0.0064600000000000005 4.882821262511316e-06 0.0064700000000000009 -5.1342758866519366e-07 0.0064800000000000005 -2.7885197784594097e-07 0.0064900000000000001 -4.8863455167268784e-06 0.0065000000000000006 -1.1567818459180456e-06 0.0065100000000000002 5.3983016421901799e-07 0.0065200000000000006 -1.5473386845904679e-07 0.0065300000000000002 6.0000640169504962e-07 0.0065400000000000007 -2.1796743121445107e-06 0.0065500000000000003 3.2827317114672173e-06 0.0065600000000000007 -5.2128324729107285e-06 0.0065700000000000003 -6.0661570137826765e-06 0.0065800000000000008 4.6081633523270007e-06 0.0065900000000000004 -6.5295417685462573e-06 0.0066000000000000008 1.9519840232988678e-06 0.0066100000000000004 5.0566397691086919e-06 0.0066200000000000009 -1.9646254769381554e-06 0.0066300000000000005 -5.2194586117426239e-06 0.0066400000000000009 2.0672715318953022e-06 0.0066500000000000005 2.0769913838929836e-06 0.0066600000000000001 6.854156138356868e-06 0.0066700000000000006 -7.2738362273085901e-06 0.0066800000000000002 -1.5987142261127439e-06 0.0066900000000000006 -2.7535540521176291e-06 0.0067000000000000002 -8.8174835840720838e-07 0.0067100000000000007 3.5252811521175366e-06 0.0067200000000000003 -4.2218644803012643e-06 0.0067300000000000007 -4.940324672586416e-07 0.0067400000000000003 -1.2643884417645716e-06 0.0067500000000000008 9.2820471902061141e-07 0.0067600000000000004 7.2457343018646942e-06 0.0067700000000000008 3.0582230332383074e-06 0.0067800000000000004 -1.1550888996586029e-06 0.0067900000000000009 3.3447749492685198e-06 0.0068000000000000005 2.9500588319315636e-06 0.0068100000000000009 -6.5988600111728451e-06 0.0068200000000000005 5.2839321307750544e-06 0.0068300000000000001 -7.7002101057542402e-07 0.0068400000000000006 5.4598674826254487e-06 0.0068500000000000002 2.8344574599554848e-08 0.0068600000000000006 -1.9931433691765139e-07 0.0068700000000000002 -3.9032359580458155e-06 0.0068800000000000007 8.1199921154280494e-06 0.0068900000000000003 1.6093145951568427e-06 0.0069000000000000008 3.2910251252259929e-06 0.0069100000000000003 2.1315673920504467e-06 0.0069200000000000008 5.4402443611435326e-06 0.0069300000000000004 7.485907146752682e-06 0.0069400000000000009 -3.3363003876460896e-06 0.0069500000000000004 4.9837223618866143e-06 0.0069600000000000009 3.8615078940725402e-06 0.0069700000000000005 8.1562553017601296e-07 0.006980000000000001 3.1765841534717014e-06 0.0069900000000000006 4.2951531134631056e-06 0.0070000000000000001 4.6647068674103858e-06 0.0070100000000000006 5.0314042361193795e-06 0.0070200000000000002 -4.5837876830560375e-06 0.0070300000000000007 3.1772045172344113e-06 0.0070400000000000003 6.5056512742850686e-07 0.0070500000000000007 -4.9399036869023577e-06 0.0070600000000000003 3.8489152817707648e-06 0.0070700000000000008 3.3053218575088118e-06 0.0070800000000000004 -5.8384846451759281e-06 0.0070900000000000008 3.1995300156148428e-06 0.0071000000000000004 4.9660672628442433e-07 0.0071100000000000009 -3.0691605956145094e-06 0.0071200000000000005 1.6246014393889269e-06 0.0071300000000000009 -2.0379312822935272e-06 0.0071400000000000005 3.0346589125854408e-06 0.007150000000000001 -4.6169015691788627e-06 0.0071600000000000006 -7.9510586152419227e-07 0.0071700000000000002 -3.5176644131656913e-06 0.0071800000000000006 4.9918640071153244e-06 0.0071900000000000002 5.5399761839897015e-07 0.0072000000000000007 4.5169577855019303e-06 0.0072100000000000003 6.2676713082771549e-06 0.0072200000000000007 -5.5450680170871377e-06 0.0072300000000000003 -4.8489207485293572e-06 0.0072400000000000008 -3.0495185872864801e-06 0.0072500000000000004 1.0477011758070629e-09 0.0072600000000000008 -2.5628155231959981e-07 0.0072700000000000004 3.452447049529991e-07 0.0072800000000000009 9.8074823030407901e-06 0.0072900000000000005 1.8059379217841308e-06 0.0073000000000000009 2.8847435219970885e-06 0.0073100000000000005 -1.1752061167154648e-07 0.007320000000000001 8.4262164921944483e-06 0.0073300000000000006 -5.6309273514756805e-06 0.0073400000000000002 2.041255653155443e-06 0.0073500000000000006 3.1952031986998812e-06 0.0073600000000000002 -4.0008556893465818e-07 0.0073700000000000007 -1.1796588543890172e-06 0.0073800000000000003 1.0723672937175791e-06 0.0073900000000000007 -1.8392831104968571e-06 0.0074000000000000003 2.161003192368131e-06 0.0074100000000000008 -3.3030392740354754e-06 0.0074200000000000004 -9.4670239599105438e-06 0.0074300000000000008 4.9050043296162533e-06 0.0074400000000000004 5.4605703742508778e-06 0.0074500000000000009 -4.6779897621024104e-06 0.0074600000000000005 -1.056857067088081e-05 0.0074700000000000009 3.0910221924083988e-06 0.0074800000000000005 1.2757774029012792e-06 0.007490000000000001 -3.8188965705837845e-06 0.0075000000000000006 5.157666988291884e-06 0.0075100000000000002 -4.8382375818608273e-06 0.0075200000000000006 1.3363994877971687e-06 0.0075300000000000002 -7.4497800389412002e-06 0.0075400000000000007 3.0852450508924359e-06 0.0075500000000000003 -9.0953158905238514e-07 0.0075600000000000007 -3.5375408805879807e-06 0.0075700000000000003 -4.6645279786733603e-06 0.0075800000000000008 2.6597513947336529e-06 0.0075900000000000004 1.6561748780905155e-06 0.0076000000000000009 3.027060904944835e-06 0.0076100000000000004 -5.0711087791928645e-06 0.0076200000000000009 -4.8111472878114725e-06 0.0076300000000000005 6.1693405244222658e-06 0.007640000000000001 -1.3849019095396538e-05 0.0076500000000000005 2.8064954879291423e-07 0.007660000000000001 1.194956285076107e-07 0.0076700000000000006 -6.9722749220932994e-06 0.0076800000000000011 -4.1819981917936604e-06 0.0076900000000000007 4.4987290941803381e-06 0.0077000000000000002 -1.0535438084643427e-06 0.0077100000000000007 -2.7063797306010681e-06 0.0077200000000000003 8.6364821074459855e-06 0.0077300000000000008 4.6031229270922426e-06 0.0077400000000000004 -3.3289860562397951e-06 0.0077500000000000008 -1.0803734032763135e-05 0.0077600000000000004 7.9925932318650604e-06 0.0077700000000000009 1.2243013366654056e-05 0.0077800000000000005 6.9118209970784152e-06 0.0077900000000000009 3.0100896119073357e-06 0.0078000000000000005 -3.3447821049850998e-06 0.007810000000000001 -3.691488440368185e-06 0.0078200000000000006 1.0491047922012557e-06 0.0078300000000000002 1.3036015596356931e-05 0.0078400000000000015 -4.3774019716532719e-06 0.0078500000000000011 -1.4092511464597064e-06 0.0078600000000000007 8.8624712854362789e-06 0.0078700000000000003 -7.7438410314871174e-06 0.0078799999999999999 -1.7161046568393641e-07 0.0078900000000000012 4.7787859737798994e-06 0.0079000000000000008 4.7167302769816843e-06 0.0079100000000000004 -5.0934829509152159e-07 0.00792 6.1359061547114764e-06 0.0079300000000000013 -1.2454120978795706e-06 0.0079400000000000009 1.8372418952416498e-06 0.0079500000000000005 -1.3904880878872363e-06 0.0079600000000000001 -3.8961469527571821e-06 0.0079700000000000014 -1.3478992318398612e-06 0.007980000000000001 1.3227809303858837e-05 0.0079900000000000006 -5.6044049364511909e-06 0.0080000000000000002 2.7515239695468638e-06 0.0080100000000000015 7.6088684012576132e-07 0.0080200000000000011 3.5190036334084139e-06 0.0080300000000000007 -4.0069139753318388e-06 0.0080400000000000003 1.8561526356810284e-06 0.0080499999999999999 -4.5004558641257077e-06 0.0080600000000000012 6.6689189082022463e-06 0.0080700000000000008 -9.5433378785720366e-07 0.0080800000000000004 -1.5406357961696092e-06 0.00809 -2.2837034658771175e-06 0.0081000000000000013 4.0488360389111844e-06 0.0081100000000000009 2.4299169845188293e-06 0.0081200000000000005 4.2034796750831987e-06 0.0081300000000000001 -5.6122238751872804e-06 0.0081400000000000014 5.2336929345099049e-06 0.008150000000000001 5.503242461473295e-10 0.0081600000000000006 6.8583613826415387e-06 0.0081700000000000002 -1.5976762228222703e-06 0.0081800000000000015 1.1602941964694197e-05 0.0081900000000000011 -6.3575382046222615e-06 0.0082000000000000007 -1.0459357315454379e-05 0.0082100000000000003 4.8303861374619789e-06 0.0082199999999999999 -1.556926198007509e-06 0.0082300000000000012 7.1167528298092681e-06 0.0082400000000000008 -7.4363379748295715e-06 0.0082500000000000004 -4.8712611463038415e-06 0.00826 1.9481887791345816e-06 0.0082700000000000013 6.920047822776397e-06 0.0082800000000000009 -1.4427304783504887e-06 0.0082900000000000005 -4.4213385857873383e-06 0.0083000000000000001 -3.6092838770178103e-06 0.0083100000000000014 1.0859265130514467e-05 0.008320000000000001 -1.3952557788018894e-06 0.0083300000000000006 2.6471598669263398e-07 0.0083400000000000002 4.3729434353157792e-06 0.0083500000000000015 8.7166742575428253e-06 0.0083600000000000011 1.1400694270814787e-06 0.0083700000000000007 1.5193613984713837e-07 0.0083800000000000003 4.1953099423849173e-06 0.0083899999999999999 -7.9736599857041379e-07 0.0084000000000000012 1.9191199459251897e-06 0.0084100000000000008 -5.7887200006537861e-07 0.0084200000000000004 -5.6533630341514676e-06 0.00843 -6.5833959028430384e-06 0.0084400000000000013 -1.3899272945269582e-06 0.0084500000000000009 1.2720031202898317e-06 0.0084600000000000005 1.0860709933158811e-05 0.0084700000000000001 -4.4319029889248508e-06 0.0084800000000000014 1.2412538397823622e-06 0.008490000000000001 -5.6014632313111785e-06 0.0085000000000000006 1.0147453553884592e-05 0.0085100000000000002 3.2272655064595976e-06 0.0085200000000000015 -5.3951009376300211e-06 0.0085300000000000011 2.9798182013253014e-06 0.0085400000000000007 -2.232784739280887e-07 0.0085500000000000003 2.5041354512683695e-06 0.0085599999999999999 -5.0025452485243216e-06 0.0085700000000000012 3.0767035416810019e-06 0.0085800000000000008 -3.9242551547139425e-06 0.0085900000000000004 -8.7415550255714829e-07 0.0086 -2.4418039847770516e-06 0.0086100000000000013 2.3926174061815929e-06 0.0086200000000000009 4.5231208032334102e-06 0.0086300000000000005 -3.8825808823835668e-06 0.0086400000000000001 4.0583011509554912e-06 0.0086500000000000014 -3.3574689439607892e-06 0.008660000000000001 1.5356757765356981e-06 0.0086700000000000006 -7.3887939492723027e-06 0.0086800000000000002 2.0982268492849447e-07 0.0086900000000000015 4.7295485037084436e-06 0.0087000000000000011 1.3946290993583722e-06 0.0087100000000000007 -3.0990024248684152e-06 0.0087200000000000003 -2.9278591294590857e-06 0.0087299999999999999 -2.267049476179714e-07 0.0087400000000000012 -1.0852267046405611e-06 0.0087500000000000008 4.0209158132209693e-06 0.0087600000000000004 4.25462168515423e-06 0.00877 -4.1515984869146287e-06 0.0087800000000000013 2.8027174804415961e-06 0.0087900000000000009 -5.1106349554110402e-06 0.0088000000000000005 -4.9374796611168943e-06 0.0088100000000000001 -1.3496698110017315e-05 0.0088200000000000014 -1.8166317678952588e-06 0.008830000000000001 9.5009634507639953e-06 0.0088400000000000006 -3.8671905579242556e-06 0.0088500000000000002 -5.825339339618906e-07 0.0088600000000000016 7.7506110016041494e-07 0.0088700000000000011 1.4888134182544938e-06 0.0088800000000000007 1.1753726081835621e-05 0.0088900000000000003 -3.3880391449124371e-06 0.0088999999999999999 4.3554581700345976e-06 0.0089100000000000013 -9.0605402751292017e-06 0.0089200000000000008 2.9300973130690637e-06 0.0089300000000000004 2.0030548365214458e-06 0.00894 -3.7174831613464634e-06 0.0089500000000000014 1.3284490538157518e-06 0.0089600000000000009 2.5557243358991524e-06 0.0089700000000000005 1.3340970076320843e-06 0.0089800000000000001 -7.5770050288448659e-06 0.0089900000000000015 -1.4749498049910765e-06 0.0090000000000000011 6.5457805565117403e-06 0.0090100000000000006 -2.1983131196022752e-06 0.0090200000000000002 1.9894972856665662e-06 0.0090300000000000016 -4.8775305003571925e-06 0.0090400000000000012 -1.5334391682188718e-06 0.0090500000000000008 5.2964566299939137e-06 0.0090600000000000003 -6.1926778493863625e-07 0.0090699999999999999 4.2823834318023908e-07 0.0090800000000000013 3.0735154310992126e-06 0.0090900000000000009 6.7439188908303088e-06 0.0091000000000000004 -1.6455251145777824e-06 0.00911 -1.3660926825580317e-06 0.0091200000000000014 2.7453384259856666e-07 0.009130000000000001 1.5113694532473314e-06 0.0091400000000000006 2.8114629216025133e-06 0.0091500000000000001 -2.5712021548493831e-06 0.0091600000000000015 -7.7893953183366521e-06 0.0091700000000000011 -2.8323707608081131e-07 0.0091800000000000007 -8.215839051892132e-06 0.0091900000000000003 -2.3442552383697724e-06 0.0092000000000000016 3.776375394723344e-06 0.0092100000000000012 5.8073920168802268e-06 0.0092200000000000008 -3.6607039147072255e-06 0.0092300000000000004 -8.5592455825093676e-07 0.0092399999999999999 -4.4972954782323183e-06 0.0092500000000000013 -5.382475879204432e-07 0.0092600000000000009 -2.2621127452356347e-06 0.0092700000000000005 3.9448121113112722e-06 0.0092800000000000001 2.3684514110069837e-06 0.0092900000000000014 -2.1378977228936544e-06 0.009300000000000001 -5.2685595828486804e-06 0.0093100000000000006 -7.6887534128552747e-07 0.0093200000000000002 1.7634861303964006e-06 0.0093300000000000015 4.9895940909597756e-06 0.0093400000000000011 8.4502555404179134e-07 0.0093500000000000007 -3.0477245232974079e-06 0.0093600000000000003 3.7082100050798876e-06 0.0093700000000000016 -3.9891189790094385e-06 0.0093800000000000012 3.0551393534851996e-06 0.0093900000000000008 -1.1886163552135901e-05 0.0094000000000000004 -4.5506667236310717e-06 0.00941 4.9143267037472691e-06 0.0094200000000000013 1.0955144379108051e-05 0.0094300000000000009 -3.7558575927878611e-06 0.0094400000000000005 1.3425213697548299e-05 0.0094500000000000001 8.7509021818695036e-06 0.0094600000000000014 3.1390455571242639e-06 0.009470000000000001 2.6238711628086854e-06 0.0094800000000000006 3.5088116557312162e-06 0.0094900000000000002 -2.6623137194102382e-06 0.0095000000000000015 7.4263250277401592e-06 0.0095100000000000011 -1.91578561793639e-06 0.0095200000000000007 3.7277405975218105e-06 0.0095300000000000003 -8.7797538344626414e-07 0.0095400000000000016 2.2518966605553916e-08 0.0095500000000000012 3.8164595719172687e-06 0.0095600000000000008 4.0829302647125199e-06 0.0095700000000000004 -3.007565076076112e-06 0.00958 -2.8202493407043621e-06 0.0095900000000000013 -1.3375142606625963e-07 0.0096000000000000009 -6.3876303920029263e-06 0.0096100000000000005 7.4854969895822146e-06 0.0096200000000000001 -8.9372259341215937e-07 0.0096300000000000014 1.9203904003835185e-06 0.009640000000000001 -2.5238959699438757e-06 0.0096500000000000006 4.0024437393367354e-07 0.0096600000000000002 -4.931032588288169e-06 0.0096700000000000015 -4.6846340478985965e-06 0.0096800000000000011 1.5688528908970443e-05 0.0096900000000000007 7.1217339428645907e-06 0.0097000000000000003 8.0605717828079253e-06 0.0097100000000000016 5.9158380231669711e-06 0.0097200000000000012 5.5939203661841504e-06 0.0097300000000000008 -3.5869880763584115e-06 0.0097400000000000004 -8.7365912875511607e-07 0.00975 5.1392103827980012e-06 0.0097600000000000013 -1.5591304410381239e-06 0.0097700000000000009 -2.560044718201228e-07 0.0097800000000000005 4.3903074516975578e-08 0.0097900000000000001 3.9834790443358975e-06 0.0098000000000000014 -2.2333416478282546e-07 0.009810000000000001 2.7620296249159013e-06 0.0098200000000000006 -3.2760142375504159e-07 0.0098300000000000002 -3.2689740814737763e-06 0.0098400000000000015 -2.9126124870887351e-06 0.0098500000000000011 -3.1550002418462009e-06 0.0098600000000000007 -7.6677695721690001e-07 0.0098700000000000003 6.1111504932980998e-07 0.0098800000000000016 -3.9705132109984314e-06 0.0098900000000000012 1.7760930921131204e-06 0.0099000000000000008 7.3013821459892718e-06 0.0099100000000000004 -5.6025556676931471e-06 0.00992 2.2057288976360294e-06 0.0099300000000000013 7.3018948764658367e-06 0.0099400000000000009 -3.6574244435811596e-07 0.0099500000000000005 7.1192394626466577e-06 0.0099600000000000001 -1.6947657316581026e-06 0.0099700000000000014 -2.1948534202124337e-06 0.009980000000000001 1.1384701508073269e-06 0.0099900000000000006 5.7096236783455217e-06 0.01 2.9070546367672647e-06 0.010010000000000002 -4.8770603724821846e-06 0.010020000000000001 8.3984902183714062e-06 0.010030000000000001 7.8828499694559261e-06 0.01004 -4.3379708013040205e-06 0.010050000000000002 -2.1030031979995773e-06 0.010060000000000001 -3.9759061827092657e-06 0.010070000000000001 1.8797447590986514e-06 0.01008 -6.9925183251900927e-07 0.01009 -4.1394767379347421e-06 0.010100000000000001 4.7190314929479166e-06 0.010110000000000001 -3.4602711556374713e-06 0.010120000000000001 2.4850866356946852e-06 0.01013 5.3635205545748239e-06 0.010140000000000001 -2.0677283517327722e-06 0.010150000000000001 -3.3149858416560205e-06 0.010160000000000001 6.4701083577038935e-06 0.01017 1.3408626740198123e-07 0.010180000000000002 2.87571930164236e-06 0.010190000000000001 -1.0056818680229885e-06 0.010200000000000001 5.554999410026726e-06 0.01021 3.1820184752302282e-06 0.010220000000000002 -5.8106988122812391e-06 0.010230000000000001 -7.3555118029141855e-07 0.010240000000000001 -5.8556578884082506e-06 0.01025 8.4360529342138616e-06 0.01026 4.1964635800315774e-07 0.010270000000000001 -3.3578087383607611e-06 0.010280000000000001 -2.7201563016670067e-06 0.010290000000000001 -7.466416706047436e-06 0.0103 -9.2091893916987988e-06 0.010310000000000001 -3.7210234226583552e-06 0.010320000000000001 3.2540427632821665e-06 0.010330000000000001 -8.0097028749339087e-06 0.01034 -3.7333165665031719e-06 0.010350000000000002 -4.3831725788187929e-06 0.010360000000000001 1.898868309827554e-06 0.010370000000000001 1.353868971726503e-06 0.01038 2.3797592070963868e-06 0.010390000000000002 -2.2351523941153338e-06 0.010400000000000001 -4.3440095479358556e-06 0.010410000000000001 1.1058319841745318e-05 0.01042 6.1349912463660007e-06 0.01043 -6.3268880982902877e-06 0.010440000000000001 8.4240831102867591e-06 0.010450000000000001 -7.1314080152826379e-06 0.010460000000000001 -7.4400212299138441e-06 0.01047 -2.2847779840360594e-06 0.010480000000000001 3.3707725970660893e-06 0.010490000000000001 4.1202183365948039e-06 0.010500000000000001 -2.4816426415639898e-06 0.01051 -5.4177171781191319e-06 0.010520000000000002 -7.8695781369656966e-06 0.010530000000000001 3.9776201295402921e-06 0.010540000000000001 -3.3785402201509719e-06 0.01055 8.7998142676074304e-06 0.010560000000000002 1.7070238100753725e-06 0.010570000000000001 3.6754263286244422e-06 0.010580000000000001 -7.9583135357334102e-07 0.01059 -2.9828535241856021e-06 0.0106 3.4621712554449164e-06 0.010610000000000001 -3.8035312299111739e-06 0.010620000000000001 1.0598465041640859e-06 0.010630000000000001 5.1066890753086521e-06 0.01064 -2.7180533549773653e-06 0.010650000000000001 -1.7148443177032286e-06 0.010660000000000001 -4.70984035086863e-06 0.010670000000000001 4.8494556967629761e-06 0.01068 1.0272111561960575e-05 0.010690000000000002 4.7164689681106939e-07 0.010700000000000001 -1.4649657713407086e-06 0.010710000000000001 7.2452917608618455e-06 0.01072 -1.1113107900488569e-06 0.010730000000000002 -5.4310293204536986e-06 0.010740000000000001 -3.7133815746858724e-06 0.010750000000000001 -1.0468988875111183e-05 0.01076 -1.5618590488362872e-06 0.01077 8.0084471934387567e-08 0.010780000000000001 2.9393778343821953e-06 0.010790000000000001 4.1542160800637958e-06 0.010800000000000001 -2.0590274728101021e-06 0.01081 -2.7645742511790522e-06 0.010820000000000001 3.6451377233650125e-06 0.010830000000000001 -5.3563922549646843e-06 0.010840000000000001 3.7644438021170415e-06 0.01085 1.5925999428214579e-06 0.010860000000000002 -3.3312922543555072e-06 0.010870000000000001 -1.7165009698368071e-05 0.010880000000000001 -6.9083473231239796e-06 0.01089 2.8761282791169821e-06 0.010900000000000002 3.1420588675679342e-06 0.010910000000000001 -2.4804192421828047e-06 0.010920000000000001 -6.5518473693821024e-06 0.01093 -2.3605348936875294e-06 0.01094 -2.0586797117774268e-06 0.010950000000000001 3.3624584160048958e-06 0.010960000000000001 -1.3300759578303029e-06 0.010970000000000001 -4.723608921624816e-06 0.01098 -1.6738762182969631e-06 0.010990000000000002 7.1047027853461266e-06 0.011000000000000001 1.9863231563521633e-06 0.011010000000000001 2.8555027418215293e-06 0.01102 -6.7234104976347336e-06 0.011030000000000002 1.6017325442091866e-06 0.011040000000000001 -3.055359596868007e-07 0.011050000000000001 -2.6840860485908026e-06 0.01106 -6.0191741734943989e-06 0.011070000000000002 4.106133083363501e-06 0.011080000000000001 -1.277879271447755e-05 0.011090000000000001 -2.066969610687357e-07 0.0111 7.5828005828750463e-06 0.01111 7.1459651696508551e-06 0.011120000000000001 -6.8379117619985189e-06 0.011130000000000001 6.7886662488842095e-06 0.011140000000000001 -7.145023100467373e-06 0.01115 2.2139281908103955e-06 0.011160000000000002 -7.9278827065790517e-06 0.011170000000000001 -1.0575340822403939e-05 0.011180000000000001 2.7868161541199323e-06 0.01119 6.29911562904055e-07 0.011200000000000002 1.4761433647568154e-06 0.011210000000000001 4.7078106150310583e-06 0.011220000000000001 -3.4989826783363033e-06 0.01123 2.6140671666886757e-06 0.011240000000000002 -2.8350793701461594e-06 0.011250000000000001 1.3584057325988182e-06 0.011260000000000001 -1.3294131823658152e-06 0.011270000000000001 -3.6135587873366055e-06 0.01128 -1.9474833594045924e-06 0.011290000000000001 3.2389819088660851e-06 0.011300000000000001 -2.0347705685130999e-06 0.011310000000000001 8.9857742772437075e-07 0.01132 -1.5555796344431897e-06 0.011330000000000002 -6.785836042091419e-06 0.011340000000000001 -2.81399031737968e-06 0.011350000000000001 2.7147551106963295e-06 0.01136 -1.2762884996681013e-06 0.011370000000000002 -1.0247861134743347e-05 0.011380000000000001 1.4089368919655433e-06 0.011390000000000001 -3.1833812812237226e-06 0.0114 1.2348695901437356e-06 0.011410000000000002 -4.1273904478489602e-06 0.011420000000000001 2.0864797101401079e-06 0.011430000000000001 -5.4420908730805208e-06 0.011440000000000001 -2.016331752195976e-06 0.01145 6.5067324746305463e-06 0.011460000000000001 -2.1167255983979305e-06 0.011470000000000001 1.4928254787288549e-06 0.011480000000000001 -1.8002076607446737e-06 0.01149 1.896515626050936e-06 0.011500000000000002 -5.8274780138285755e-06 0.011510000000000001 4.0772805381162225e-07 0.011520000000000001 -3.1841491279549083e-06 0.01153 -5.9243709690786602e-06 0.011540000000000002 5.3768307564559232e-06 0.011550000000000001 3.6592766752833118e-06 0.011560000000000001 4.2563958243177971e-06 0.01157 -1.0904942188937473e-05 0.011580000000000002 6.3678401818434214e-06 0.011590000000000001 5.5275645060549634e-07 0.011600000000000001 -3.7368348706785128e-06 0.011610000000000001 2.5776527925621501e-06 0.01162 -2.5186940241850492e-06 0.011630000000000001 -1.894361651017993e-06 0.011640000000000001 3.0813410837156104e-06 0.011650000000000001 6.0949319983906382e-06 0.01166 -1.245975302833011e-05 0.011670000000000002 -2.0124530506983905e-07 0.011680000000000001 9.8853784290667536e-06 0.011690000000000001 7.2060287472861831e-06 0.0117 1.7867403972071829e-06 0.011710000000000002 3.6794877171713171e-07 0.011720000000000001 -2.7846709040398988e-06 0.011730000000000001 -2.9792817508156742e-06 0.01174 -4.9399087981239631e-06 0.011750000000000002 -8.1029325229284811e-06 0.011760000000000001 -9.5299479666302456e-06 0.011770000000000001 3.9248072404735381e-06 0.011780000000000001 -4.860341245042169e-07 0.01179 6.660977470959004e-06 0.011800000000000001 -5.3742879885311538e-07 0.011810000000000001 -2.0862936414892335e-06 0.011820000000000001 1.3882954204517703e-06 0.01183 -5.9501576559195149e-06 0.011840000000000002 7.9957659797752157e-06 0.011850000000000001 9.3870306078568626e-06 0.011860000000000001 -1.2671334085239572e-06 0.01187 7.475078437099408e-06 0.011880000000000002 -2.6429097861358123e-06 0.011890000000000001 4.6868593144269194e-06 0.011900000000000001 -4.2232930205893388e-06 0.01191 -1.4627440425411394e-06 0.011920000000000002 1.9880686770698572e-06 0.011930000000000001 3.6832938568806857e-06 0.011940000000000001 3.2486366945689673e-06 0.011950000000000001 2.8624391288544114e-06 0.01196 -3.2817523199912933e-06 0.011970000000000001 -3.0036897092379476e-06 0.011980000000000001 -1.2999169141167525e-05 0.011990000000000001 -8.9765101419106032e-07 0.012 2.2206184212385357e-06 0.012010000000000002 3.1899699131510691e-06 0.012020000000000001 -2.4561756224502033e-06 0.012030000000000001 -3.2918118826122546e-06 0.01204 4.2240230219601645e-06 0.012050000000000002 -8.6300209067692718e-08 0.012060000000000001 8.6730935673548916e-06 0.012070000000000001 -2.7257904524334791e-07 0.01208 1.8634722215818375e-06 0.012090000000000002 3.3171728427720584e-06 0.012100000000000001 9.5028030329434438e-06 0.012110000000000001 -4.5948109225950339e-06 0.012120000000000001 3.2180823839119037e-06 0.01213 7.7536023901012308e-06 0.012140000000000001 6.5646720665843012e-06 0.012150000000000001 -7.2420151969766609e-07 0.012160000000000001 9.7057018402432264e-06 0.01217 -2.3943447129311224e-07 0.012180000000000002 -5.9813197985835369e-06 0.012190000000000001 4.4185389909514335e-06 0.012200000000000001 3.0329914621582873e-06 0.01221 4.9526698140161936e-06 0.012220000000000002 1.0031406653862992e-05 0.012230000000000001 4.8921444773653139e-06 0.012240000000000001 3.6559921421360588e-07 0.01225 3.4272051563443321e-06 0.012260000000000002 3.2128489626571797e-06 0.012270000000000001 -4.7864850079638483e-06 0.012280000000000001 3.0967455010025361e-06 0.012290000000000001 -8.0411752762468575e-07 0.0123 -1.1107280176495432e-05 0.012310000000000001 -1.7800456474110236e-06 0.012320000000000001 -9.067049322164105e-07 0.012330000000000001 -4.0786596515189134e-06 0.01234 -5.7356778483236912e-06 0.012350000000000002 -3.7826242332620501e-06 0.012360000000000001 3.4760193237996327e-06 0.012370000000000001 4.9655338896157793e-08 0.01238 1.2235752535298673e-06 0.012390000000000002 1.4267525990998382e-06 0.012400000000000001 3.8230280926133293e-06 0.012410000000000001 -1.8916729536774397e-06 0.01242 5.9536738304103888e-08 0.012430000000000002 9.6474914828477082e-07 0.012440000000000001 9.7869321538749139e-08 0.012450000000000001 2.6617873842766846e-06 0.012460000000000001 -9.1248951016043576e-06 0.01247 -6.5887086090765871e-07 0.012480000000000002 -3.6229955257205007e-06 0.012490000000000001 -1.3256539609896343e-06 0.012500000000000001 3.7798446805841758e-06 0.01251 9.5407350925070591e-07 0.012520000000000002 4.0983099912049453e-06 0.012530000000000001 2.3447199600036911e-06 0.012540000000000001 -7.5324909389141508e-07 0.01255 8.7101912318031322e-07 0.012560000000000002 5.0552618520120675e-06 0.012570000000000001 6.8979649804673312e-06 0.012580000000000001 1.9809942914118129e-06 0.01259 1.2250093210752758e-06 0.012600000000000002 8.5502304443027488e-06 0.012610000000000001 -1.2876041510457892e-06 0.012620000000000001 -4.3083871789537472e-06 0.012630000000000001 3.3558934659100285e-07 0.01264 8.4593820111277003e-06 0.012650000000000002 4.397109196506367e-06 0.012660000000000001 1.4115238878712622e-06 0.012670000000000001 -1.1532181338851474e-06 0.01268 -2.4007722529053419e-06 0.012690000000000002 -8.7779686250104605e-06 0.012700000000000001 -3.3014001589357954e-06 0.012710000000000001 1.0646977548613471e-05 0.01272 -1.4928409209104833e-06 0.012730000000000002 5.9980529147808198e-06 0.012740000000000001 1.6981074124888571e-06 0.012750000000000001 -2.2322978709598682e-06 0.012760000000000001 2.4611251855609651e-07 0.012770000000000002 2.3509451091303252e-06 0.012780000000000001 8.1635774938002416e-06 0.012790000000000001 1.0640510214050303e-05 0.012800000000000001 -2.5652331861246789e-06 0.01281 -6.8993190412157851e-06 0.012820000000000002 -7.0425059752144324e-06 0.012830000000000001 3.850478777734947e-06 0.012840000000000001 -6.7594799859448256e-07 0.01285 2.7885018609304136e-06 0.012860000000000002 6.7296420432824551e-06 0.012870000000000001 -6.4780092598862915e-07 0.012880000000000001 4.4097082125122449e-06 0.01289 1.4013077724243187e-05 0.012900000000000002 1.0448147270272799e-05 0.012910000000000001 -7.8563355988458109e-06 0.012920000000000001 2.9672364939706437e-06 0.012930000000000001 1.1645142598840147e-05 0.012940000000000002 -9.3396061748061425e-06 0.012950000000000001 3.9655751003836971e-06 0.012960000000000001 2.9299589903683412e-06 0.012970000000000001 1.3021098368623955e-06 0.01298 4.8768407316394786e-06 0.012990000000000002 1.6062047817481048e-07 0.013000000000000001 -2.2949038746324377e-06 0.013010000000000001 -5.8248255937018757e-06 0.01302 -5.6052640838452158e-06 0.013030000000000002 -5.4152492044048043e-06 0.013040000000000001 4.2387127968473514e-06 0.013050000000000001 -4.9908951959647498e-06 0.01306 -2.0311265873693355e-06 0.013070000000000002 2.3904833297042827e-06 0.013080000000000001 -5.900425284565254e-06 0.013090000000000001 3.2341681619136079e-06 0.013100000000000001 -3.2324369493045899e-06 0.013110000000000002 2.4523088590683088e-06 0.013120000000000001 2.0886942842991907e-06 0.013130000000000001 -4.1587676454978929e-06 0.013140000000000001 -3.1543746593089929e-06 0.01315 8.5215283564534765e-06 0.013160000000000002 -1.0276276388446841e-06 0.013170000000000001 6.1088078407643239e-06 0.013180000000000001 3.5891478342991904e-06 0.01319 2.2733649473500573e-07 0.013200000000000002 2.1292791453030719e-06 0.013210000000000001 2.5598990277857304e-06 0.013220000000000001 2.0792044265897862e-07 0.01323 -4.6724082513892946e-06 0.013240000000000002 -9.0148136418795254e-06 0.013250000000000001 5.2526182114481581e-07 0.013260000000000001 -1.9269995370293491e-06 0.013270000000000001 -9.786715965570929e-06 0.013280000000000002 -4.2590883651598534e-06 0.013290000000000001 -2.9937332614613213e-06 0.013300000000000001 1.2949258286488947e-05 0.013310000000000001 8.9766673756127965e-07 0.01332 -1.8769542280711291e-06 0.013330000000000002 -6.7022690366391991e-07 0.013340000000000001 1.4335086747776686e-05 0.013350000000000001 4.5279075310990972e-07 0.01336 5.7344780263299672e-06 0.013370000000000002 -7.5280397886215575e-06 0.013380000000000001 1.10873412238233e-05 0.013390000000000001 7.7070636501278958e-09 0.0134 2.8666699155696265e-06 0.013410000000000002 2.252909752094187e-06 0.013420000000000001 -4.960065478107157e-06 0.013430000000000001 -1.1085008764725909e-07 0.013440000000000001 3.323275502211119e-06 0.013450000000000002 5.2289114023476787e-06 0.013460000000000001 -7.3715537504330384e-07 0.013470000000000001 -2.8513210995701083e-06 0.013480000000000001 7.2882696947215159e-06 0.01349 -2.4720720190297396e-06 0.013500000000000002 -3.0781615706922014e-06 0.013510000000000001 -1.6485466689022356e-06 0.013520000000000001 2.149426113833975e-06 0.01353 1.8577868120183612e-06 0.013540000000000002 7.3799648745848643e-06 0.013550000000000001 2.4540387217099977e-06 0.013560000000000001 8.8363107714206571e-07 0.01357 5.9847261421465738e-06 0.013580000000000002 1.6617746531794606e-06 0.013590000000000001 1.1608620546324157e-06 0.013600000000000001 -4.8884050863856349e-07 0.013610000000000001 -8.6598395041623989e-06 0.013620000000000002 -9.5889690861103683e-06 0.013630000000000001 1.1897635132241223e-05 0.013640000000000001 -9.2936963851955511e-07 0.013650000000000001 -6.2944495738299106e-06 0.01366 -4.3124156512463694e-06 0.013670000000000002 -3.2535131124707402e-06 0.013680000000000001 9.0451248479802704e-06 0.013690000000000001 1.0677889442768486e-06 0.0137 -4.1671944987304215e-07 0.013710000000000002 1.9589053844042495e-06 0.013720000000000001 5.1307317914801267e-06 0.013730000000000001 8.7156069901905612e-07 0.01374 -2.1985415773948886e-06 0.013750000000000002 2.8093520313454805e-06 0.013760000000000001 1.9175854948573834e-07 0.013770000000000001 3.71360630902227e-06 0.013780000000000001 -1.0008168473435038e-05 0.013790000000000002 2.3611306719035912e-06 0.013800000000000002 1.0934113717378917e-06 0.013810000000000001 1.2598629091863148e-05 0.013820000000000001 -8.8238719002301603e-07 0.01383 2.6913272570791638e-06 0.013840000000000002 -8.4592939435672319e-07 0.013850000000000001 -2.6765218632360591e-06 0.013860000000000001 9.80466090506949e-06 0.01387 1.7896465986961065e-06 0.013880000000000002 -3.5586148487496879e-06 0.013890000000000001 2.9196730630896512e-06 0.013900000000000001 -2.2991614103080874e-06 0.01391 4.1945344658956427e-06 0.013920000000000002 -8.7957529061634665e-07 0.013930000000000001 3.7312861259360605e-06 0.013940000000000001 -8.0010106117747035e-07 0.013950000000000001 6.062501721051061e-07 0.013960000000000002 -1.0101931554280706e-05 0.013970000000000002 2.2645769920359649e-06 0.013980000000000001 -4.1783060926427878e-06 0.013990000000000001 -5.3915192743890535e-06 0.014 2.6606970256471997e-07 0.014010000000000002 -2.260590336007044e-06 0.014020000000000001 -2.9772960137029633e-06 0.014030000000000001 -1.7065193485394151e-06 0.01404 5.6203793683554795e-06 0.014050000000000002 4.7518153690303586e-06 0.014060000000000001 1.0807547091124324e-05 0.014070000000000001 3.7561839758748287e-07 0.014080000000000001 -3.8380351444503682e-06 0.014090000000000002 1.987583334987356e-06 0.014100000000000001 8.8554074515728349e-08 0.014110000000000001 3.8336858606063504e-06 0.014120000000000001 1.4074632915732778e-06 0.014130000000000002 -2.5653330860798877e-06 0.014140000000000002 -5.5801656404229035e-06 0.014150000000000001 -2.6281346815921809e-06 0.014160000000000001 3.6056366741422487e-06 0.01417 5.8369227531200244e-06 0.014180000000000002 5.6451791692766311e-07 0.014190000000000001 5.3863365117304401e-06 0.014200000000000001 -1.0770660028984645e-05 0.01421 3.3173739694982719e-06 0.014220000000000002 -1.3933288046040667e-05 0.014230000000000001 -5.8990815365245573e-06 0.014240000000000001 2.5399304464907905e-06 0.014250000000000001 2.6388133752348106e-07 0.014260000000000002 -1.5543956894295395e-06 0.014270000000000001 -5.0432206849126707e-06 0.014280000000000001 6.7746125642873254e-07 0.014290000000000001 9.3495279222095861e-07 0.014300000000000002 2.2041087488171492e-07 0.014310000000000002 5.9840521426039691e-07 0.014320000000000001 -1.47026828557787e-06 0.014330000000000001 2.0496978709802777e-06 0.01434 5.8584334773925446e-06 0.014350000000000002 3.1437973564782258e-07 0.014360000000000001 -1.9817138920448733e-06 0.014370000000000001 -2.5274717861475111e-06 0.01438 -1.7506271538711462e-06 0.014390000000000002 -7.3092696009852157e-06 0.014400000000000001 6.6672709681919388e-06 0.014410000000000001 -4.0281484426069082e-06 0.014420000000000001 -1.1405239533403773e-06 0.014430000000000002 5.7180128874315709e-06 0.014440000000000001 2.1884118374917108e-06 0.014450000000000001 -2.678325390445357e-06 0.014460000000000001 -2.7954479265510969e-06 0.014470000000000002 2.8673168207824671e-06 0.014480000000000002 -1.7429278515728689e-06 0.014490000000000001 -2.2052148781220135e-06 0.014500000000000001 2.6087028784291685e-06 0.01451 3.6624129423551897e-06 0.014520000000000002 7.4255104092894183e-07 0.014530000000000001 -1.2193220583237039e-06 0.014540000000000001 -2.9820842212568357e-06 0.01455 -5.9620673035197197e-06 0.014560000000000002 8.3575108944187315e-06 0.014570000000000001 7.9646119171027752e-07 0.014580000000000001 1.1077806374880695e-05 0.014590000000000001 -3.2510558026175551e-07 0.014600000000000002 -7.8096296690286749e-07 0.014610000000000001 4.9490914798492747e-08 0.014620000000000001 1.7059365610527264e-08 0.014630000000000001 1.0427380882616075e-06 0.014640000000000002 2.4045093132560697e-06 0.014650000000000002 -1.0915896246338603e-06 0.014660000000000001 -1.8869607399925025e-06 0.014670000000000001 -4.0088574754990065e-06 0.01468 4.1235944940071188e-06 0.014690000000000002 5.6354954778823535e-06 0.014700000000000001 -2.6208086741063034e-06 0.014710000000000001 -9.5810128387144452e-08 0.01472 5.3126506957319724e-06 0.014730000000000002 7.8285689795668549e-06 0.014740000000000001 -3.217364504264704e-07 0.014750000000000001 5.3402012858021068e-06 0.014760000000000001 -2.2840978191372675e-07 0.014770000000000002 3.8796401334502894e-06 0.014780000000000001 -2.9885174704543945e-06 0.014790000000000001 -1.8444483081028159e-07 0.014800000000000001 8.8752697230690162e-06 0.014810000000000002 -3.7050418238352664e-07 0.014820000000000002 6.8365221342645662e-07 0.014830000000000001 1.994585459694668e-06 0.014840000000000001 3.2099002575601462e-06 0.01485 1.2518980329422292e-06 0.014860000000000002 7.942038672205298e-06 0.014870000000000001 -1.5282183484459585e-06 0.014880000000000001 -7.268290486424226e-07 0.01489 3.5580242550234311e-06 0.014900000000000002 5.0944288126771095e-06 0.014910000000000001 -2.5122626452830987e-06 0.014920000000000001 -1.5412040908099298e-07 0.014930000000000001 2.4844731857208578e-06 0.014940000000000002 2.5618933410369402e-07 0.014950000000000001 9.4357102118417415e-06 0.014960000000000001 4.2374430510031542e-06 0.014970000000000001 1.1518269938407983e-06 0.014980000000000002 9.1894817107572055e-07 0.014990000000000002 1.4285362197108514e-05 0.015000000000000001 -1.2272723617853855e-05 0.015010000000000001 6.8069900822205018e-06 0.01502 1.0625438335412406e-06 0.015030000000000002 8.2918761140065591e-06 0.015040000000000001 -3.7037410245874546e-06 0.015050000000000001 2.6545995811327132e-06 0.01506 -3.432690495907875e-06 0.015070000000000002 7.528259214807967e-06 0.015080000000000001 4.6272508515874947e-06 0.015090000000000001 -1.0184956751567288e-06 0.015100000000000001 3.1505775128575011e-06 0.015110000000000002 -1.4876063759478518e-06 0.015120000000000001 7.0913033866371708e-06 0.015130000000000001 -7.2167051352454849e-06 0.015140000000000001 -4.2618132026743643e-06 0.015150000000000002 3.75348959066266e-06 0.015160000000000002 7.9016938518292121e-06 0.015170000000000001 -2.7478165526386379e-06 0.015180000000000001 -4.5715261413710801e-06 0.01519 -5.5593228409999049e-07 0.015200000000000002 -6.8637165327167265e-06 0.015210000000000001 4.2425228981283658e-07 0.015220000000000001 8.8999224476549554e-06 0.01523 -9.7600619743500832e-06 0.015240000000000002 -3.6116027816516305e-07 0.015250000000000001 6.355122765358415e-06 0.015260000000000001 1.6982553691977406e-06 0.015270000000000001 1.7182777604857909e-06 0.015280000000000002 1.0305989118466282e-06 0.015290000000000002 -7.599067245446595e-07 0.015300000000000001 1.5790286257479657e-06 0.015310000000000001 -1.4948820441350531e-07 0.015320000000000002 1.0050172732388321e-05 0.015330000000000002 -5.3221162896607521e-06 0.015340000000000001 -2.3210421366149438e-07 0.015350000000000001 -3.8532857203728621e-06 0.015360000000000002 -1.2888774693016623e-06 0.015370000000000002 -8.5221511705992426e-07 0.015380000000000001 -3.120981663333733e-06 0.015390000000000001 2.3687717159480959e-06 0.0154 1.2258348270043508e-06 0.015410000000000002 -1.8385791211733464e-06 0.015420000000000001 -1.9891193770307469e-06 0.015430000000000001 8.1040684238781059e-07 0.015440000000000001 -1.1134534773792898e-06 0.015450000000000002 -3.2158258299491629e-06 0.015460000000000002 -9.4427933714710624e-06 0.015470000000000001 -8.3270197904416405e-07 0.015480000000000001 2.3740146537938797e-06 0.015490000000000002 1.8333103016114825e-07 0.015500000000000002 3.3914062241830624e-06 0.015510000000000001 -4.7378702498331407e-06 0.015520000000000001 6.0158922221832304e-06 0.015530000000000002 -3.2144298964666805e-06 0.015540000000000002 1.9223522785989352e-06 0.015550000000000001 -6.0143509868779973e-06 0.015560000000000001 -1.004786077973731e-06 0.015570000000000001 6.1105619137099989e-06 0.015580000000000002 7.3239566191787713e-06 0.015590000000000001 -5.1308999893416746e-06 0.015600000000000001 -7.8131544825827026e-07 0.015610000000000001 -6.1390878269273007e-07 0.015620000000000002 -5.6618065231041594e-06 0.015630000000000002 -3.4714411478240637e-06 0.015640000000000001 6.991719009446821e-06 0.015650000000000001 6.7667887697327483e-06 0.01566 -6.6561129481837194e-06 0.01567 5.2597458916263888e-06 0.015680000000000003 1.8601788534402795e-06 0.015690000000000003 5.3013350549107797e-06 0.015700000000000002 -9.7047360061995995e-07 0.015710000000000002 4.3008621917153282e-06 0.015720000000000001 6.1376369913744719e-06 0.015730000000000001 -6.4005843828197295e-07 0.015740000000000001 6.1073039351927241e-06 0.01575 -6.4853451701414153e-06 0.01576 3.0224919475554715e-06 0.015770000000000003 4.0321373212762251e-06 0.015780000000000002 -3.3009869834980492e-06 0.015790000000000002 6.1018874468938819e-07 0.015800000000000002 -9.5860597828917152e-06 0.015810000000000001 1.812808157203271e-06 0.015820000000000001 4.0308505353173998e-06 0.01583 2.4176327014131529e-07 0.01584 3.7774127214159613e-06 0.015850000000000003 -1.2222518364467204e-07 0.015860000000000003 2.5503213372040796e-06 0.015870000000000002 -8.1593487109604751e-06 0.015880000000000002 2.5981448903726565e-06 0.015890000000000001 2.2207374300547411e-07 0.015900000000000001 -3.2294423410424881e-06 0.015910000000000001 -8.0408018509268276e-06 0.01592 -5.0930453743232564e-06 0.01593 -4.1307119224359127e-06 0.015940000000000003 -3.710187960482949e-06 0.015950000000000002 -3.2942165635330424e-07 0.015960000000000002 -1.4756208457043122e-06 0.015970000000000002 -4.7329183409256538e-06 0.015980000000000001 5.0860094891432867e-06 0.015990000000000001 -1.1308546968339976e-05 0.016 -1.4343917468429417e-06 0.01601 2.4105017149928456e-06 0.016020000000000003 -3.2099461205846153e-06 0.016030000000000003 -3.9811076829082722e-06 0.016040000000000002 7.432373879250615e-06 0.016050000000000002 8.9149614828508827e-06 0.016060000000000001 -3.0774912369837981e-07 0.016070000000000001 -1.2882604045187411e-06 0.016080000000000001 -3.5800087895199694e-06 0.01609 4.82778915720887e-06 0.0161 2.8553425290250019e-06 0.016110000000000003 -1.0090996765960128e-05 0.016120000000000002 9.9334226903883222e-07 0.016130000000000002 1.4738908305293225e-06 0.016140000000000002 9.2604451084421385e-06 0.016150000000000001 -7.2410121100814455e-06 0.016160000000000001 -7.5296386148441306e-06 0.01617 9.7912669222303462e-06 0.01618 3.5358351774148646e-06 0.016190000000000003 3.2767561894787997e-06 0.016200000000000003 -7.6725582521668941e-06 0.016210000000000002 7.2412088476418644e-06 0.016220000000000002 -6.742847789920788e-06 0.016230000000000001 -1.9563531046841313e-06 0.016240000000000001 -1.2265498649783928e-05 0.016250000000000001 -5.7049640684583466e-06 0.01626 -2.5832059719612518e-06 0.01627 -2.3068856592998845e-06 0.016280000000000003 -1.5903183788392257e-05 0.016290000000000002 -1.3447925103574549e-06 0.016300000000000002 -5.5817338666039236e-06 0.016310000000000002 6.9751800121579505e-07 0.016320000000000001 3.4670864125869731e-06 0.016330000000000001 -5.1873457632454705e-06 0.01634 1.5393084997200589e-07 0.01635 6.7099002865711495e-06 0.016360000000000003 -8.0076818147828712e-07 0.016370000000000003 -5.3019415731108867e-06 0.016380000000000002 2.0438810854568853e-06 0.016390000000000002 7.0856653258610099e-06 0.016400000000000001 3.5263726040991866e-07 0.016410000000000001 -3.4294029551112018e-06 0.016420000000000001 -3.1095667946608897e-06 0.01643 -5.2798139182553268e-06 0.01644 -1.0838706909933947e-05 0.016450000000000003 1.5939966906828208e-06 0.016460000000000002 -1.3900558574073611e-07 0.016470000000000002 5.3763230369390993e-06 0.016480000000000002 2.3533182111311127e-06 0.016490000000000001 1.3429433829760307e-07 0.016500000000000001 5.4665504497418997e-06 0.01651 -9.4994119267514304e-06 0.01652 -3.1736128961442668e-06 0.016530000000000003 -3.7742858848567919e-07 0.016540000000000003 7.1763544024259822e-06 0.016550000000000002 -4.5293870424012001e-06 0.016560000000000002 -2.3122637436426153e-06 0.016570000000000001 3.3869358220645543e-06 0.016580000000000001 -2.69207062270305e-06 0.016590000000000001 -8.7899214005656512e-07 0.0166 6.4135620400733082e-07 0.01661 3.569277065916147e-06 0.016620000000000003 -5.3952344529951922e-07 0.016630000000000002 8.8160188249966982e-07 0.016640000000000002 1.6962621001044877e-07 0.016650000000000002 -2.2504866363781427e-06 0.016660000000000001 6.3245402869572717e-06 0.016670000000000001 -1.4824849889990367e-05 0.01668 -3.8923083767522126e-06 0.01669 1.577860686318863e-07 0.016700000000000003 -4.1840735000020518e-06 0.016710000000000003 -6.6100978035192949e-06 0.016720000000000002 -2.2230124104125538e-06 0.016730000000000002 -5.4784871227522479e-07 0.016740000000000001 -5.4666590609123661e-06 0.016750000000000001 -4.0483436682194513e-06 0.016760000000000001 4.5765095885017457e-06 0.01677 -4.0799536230683292e-06 0.01678 7.7334742590627523e-07 0.016790000000000003 -2.1869017280860976e-06 0.016800000000000002 -3.219089789396989e-06 0.016810000000000002 -4.4371967816155191e-06 0.016820000000000002 -6.763190813495385e-06 0.016830000000000001 -1.5994725081360557e-05 0.016840000000000001 -3.1564725770444994e-06 0.01685 9.106414206131583e-06 0.01686 -4.6626454907211407e-06 0.016870000000000003 5.3575948448523198e-06 0.016880000000000003 1.5475016944343445e-06 0.016890000000000002 6.1146878569422387e-06 0.016900000000000002 1.5497370626435404e-06 0.016910000000000001 6.2878688825713034e-06 0.016920000000000001 -4.210059917111505e-06 0.016930000000000001 1.1490711616678815e-06 0.01694 -1.4899593504744073e-06 0.01695 -5.228610312372273e-06 0.016960000000000003 -5.265956571831878e-06 0.016970000000000002 -1.6379541513082303e-06 0.016980000000000002 -1.0753863229698724e-05 0.016990000000000002 2.1479672043900668e-06 0.017000000000000001 -3.6151551322814466e-06 0.017010000000000001 -5.9653480762020608e-07 0.01702 -9.9018220011424314e-06 0.01703 -1.6939178489061429e-06 0.017040000000000003 7.3289829154864913e-06 0.017050000000000003 -1.0437789961727614e-06 0.017060000000000002 -5.4391296483136725e-06 0.017070000000000002 -1.2189050550125202e-07 0.017080000000000001 6.5284012738583981e-07 0.017090000000000001 -9.3454156498412137e-06 0.017100000000000001 1.1887764203082219e-06 0.01711 -2.33930242640885e-06 0.01712 -1.0994374588608402e-05 0.017130000000000003 3.2673258198867942e-06 0.017140000000000002 -2.1397253689932145e-06 0.017150000000000002 1.674053000500398e-06 0.017160000000000002 4.3151853202437912e-06 0.017170000000000001 -1.0471426312547015e-05 0.017180000000000001 1.6181589775274324e-06 0.01719 -2.2736648530656744e-07 0.0172 8.5260735954299567e-07 0.017210000000000003 -6.930414486037698e-06 0.017220000000000003 -7.3273781490732258e-06 0.017230000000000002 -7.3683725601465486e-06 0.017240000000000002 -6.9531644804279563e-06 0.017250000000000001 3.0683383072610378e-06 0.017260000000000001 3.9964040238456432e-06 0.017270000000000001 -6.4929363075180248e-06 0.01728 -1.4548125443402561e-06 0.01729 2.2772549720269178e-06 0.017300000000000003 7.7014884194693612e-07 0.017310000000000002 -1.8884668297430201e-06 0.017320000000000002 4.9570402150561295e-06 0.017330000000000002 -1.9732583817276182e-06 0.017340000000000001 -1.4324368263463279e-06 0.017350000000000001 6.5853794602587577e-06 0.01736 1.3237267994562133e-06 0.01737 5.7101411597308951e-06 0.017380000000000003 -3.488217880627051e-07 0.017390000000000003 6.9177119860837994e-06 0.017400000000000002 -6.2064673274115762e-06 0.017410000000000002 1.3845831117996913e-06 0.017420000000000001 2.3293179535471923e-06 0.017430000000000001 -6.1302614913431209e-06 0.017440000000000001 -8.9975898933360365e-07 0.01745 6.377411944410342e-06 0.01746 -4.3560899658179869e-06 0.017470000000000003 -1.6142916477741852e-06 0.017480000000000002 -1.1569599392355806e-06 0.017490000000000002 -4.1311313935277667e-06 0.017500000000000002 2.4622120057873884e-06 0.017510000000000001 6.1739145214316064e-06 0.017520000000000001 -6.3957770114425311e-06 0.01753 5.6108253403584725e-06 0.01754 1.2630560121607385e-05 0.017550000000000003 4.6182483796270343e-06 0.017560000000000003 2.0968575849654724e-06 0.017570000000000002 -1.040357135566674e-05 0.017580000000000002 1.744789146837936e-06 0.017590000000000001 -1.1690170114131021e-06 0.017600000000000001 8.8982338597362757e-06 0.017610000000000001 -1.6874142002515323e-06 0.01762 -3.1035941591808732e-06 0.01763 -1.3572515252803511e-06 0.017640000000000003 -1.3219286861770984e-06 0.017650000000000002 -9.1822476026394205e-06 0.017660000000000002 -1.1601509181408262e-05 0.017670000000000002 5.0922673183879408e-06 0.017680000000000001 7.3434520041597488e-06 0.017690000000000001 1.36388075444456e-06 0.0177 2.2368985636048994e-06 0.01771 -1.244215214820182e-06 0.017720000000000003 6.9892365158523478e-07 0.017730000000000003 3.3933477168288135e-07 0.017740000000000002 -1.9081141335786991e-08 0.017750000000000002 4.1261220581878655e-06 0.017760000000000001 -3.1507336429505904e-06 0.017770000000000001 8.9431264725191239e-06 0.017780000000000001 4.6153932298510502e-06 0.01779 9.4160540808871827e-07 0.0178 1.0173790598684512e-06 0.017810000000000003 -4.6396742081840817e-06 0.017820000000000003 7.0791743901849975e-06 0.017830000000000002 1.093274411631404e-06 0.017840000000000002 -4.3575478042496049e-06 0.017850000000000001 -1.6371364844102413e-08 0.017860000000000001 9.9860580957640747e-07 0.01787 -6.7183979374515833e-06 0.01788 -7.4247315007442613e-06 0.017890000000000003 -3.2630036444388884e-06 0.017900000000000003 -2.4368803794548037e-06 0.017910000000000002 -7.6703377122327118e-06 0.017920000000000002 1.9347289718712188e-07 0.017930000000000001 -6.190465199146507e-06 0.017940000000000001 1.6305870099143338e-07 0.017950000000000001 -3.8899933200731925e-06 0.01796 1.3671842165363471e-06 0.01797 -5.5031822930390407e-06 0.017980000000000003 2.5908128780779975e-06 0.017990000000000003 -6.1725501849463024e-06 0.018000000000000002 -5.5926572459912687e-06 0.018010000000000002 1.9380495318331676e-06 0.018020000000000001 4.651380122182493e-06 0.018030000000000001 2.1002518707867043e-07 0.01804 -2.0114839931800097e-06 0.01805 1.8115239763520098e-06 0.018060000000000003 -5.3550221679790047e-07 0.018070000000000003 -2.8646760449733914e-06 0.018080000000000002 1.1819485592482574e-05 0.018090000000000002 1.7145495808886707e-05 0.018100000000000002 -3.895031428170798e-07 0.018110000000000001 2.8630904268635561e-07 0.018120000000000001 -1.0298961899142087e-06 0.01813 -2.8979014563653084e-06 0.01814 -1.5446452091569548e-06 0.018150000000000003 1.7936323200757997e-06 0.018160000000000003 1.6573291841069622e-06 0.018170000000000002 3.5708244000939175e-06 0.018180000000000002 1.75177276321737e-08 0.018190000000000001 3.2299569277177585e-06 0.018200000000000001 5.4496399008705955e-06 0.01821 8.8198307502965333e-06 0.01822 5.3181576686299676e-06 0.018230000000000003 -4.574807955808426e-06 0.018240000000000003 -8.816576173757861e-06 0.018250000000000002 9.2421108608958644e-06 0.018260000000000002 -2.0029810123145168e-06 0.018270000000000002 -3.4437616660102292e-06 0.018280000000000001 3.9037319908500685e-06 0.018290000000000001 4.2687282332232064e-06 0.0183 -1.1378259227375511e-06 0.01831 -3.644585127013454e-06 0.018320000000000003 -1.1999527158302575e-05 0.018330000000000003 7.3671357099405013e-06 0.018340000000000002 -6.1248581005227799e-06 0.018350000000000002 -4.7960811475445651e-06 0.018360000000000001 -8.843744120019722e-07 0.018370000000000001 -4.5098612568317964e-06 0.018380000000000001 -5.035162084788047e-06 0.01839 7.251603925548221e-07 0.018400000000000003 4.2438914895811723e-06 0.018410000000000003 -1.9430756875871536e-06 0.018420000000000002 -1.516178162742224e-06 0.018430000000000002 -7.62746642670015e-06 0.018440000000000002 -1.0241401206867689e-06 0.018450000000000001 1.8223227884992188e-06 0.018460000000000001 -3.9662654859906581e-06 0.01847 -3.3681773112723136e-06 0.01848 -9.7731408521328978e-06 0.018490000000000003 7.2956699090250962e-06 0.018500000000000003 8.0654921208617356e-07 0.018510000000000002 5.1616149059019539e-07 0.018520000000000002 -1.8832454810043827e-07 0.018530000000000001 5.0716608985666361e-07 0.018540000000000001 6.0506176134113397e-07 0.018550000000000001 -2.9781370125867718e-06 0.01856 -1.8375569811003263e-06 0.018570000000000003 2.4254996040808054e-07 0.018580000000000003 -1.0149528924753526e-06 0.018590000000000002 -1.7106966296748434e-06 0.018600000000000002 -5.7623507929868682e-06 0.018610000000000002 4.8489632443621275e-06 0.018620000000000001 6.9959701559098327e-07 0.018630000000000001 -2.3563909827118449e-06 0.01864 7.220189053067522e-06 0.01865 -6.1267967384330271e-06 0.018660000000000003 2.6136946643686133e-06 0.018670000000000003 1.5861515190344092e-06 0.018680000000000002 2.3260032719601126e-06 0.018690000000000002 -2.8954314805668278e-06 0.018700000000000001 3.858334551650576e-06 0.018710000000000001 2.9983845792144633e-06 0.018720000000000001 1.4530133337228686e-06 0.01873 1.2871776781169478e-06 0.018740000000000003 3.2929302326191013e-06 0.018750000000000003 -5.9636725838082502e-06 0.018760000000000002 -3.9477751050450083e-06 0.018770000000000002 -3.0330314067690989e-06 0.018780000000000002 8.6215001965293742e-06 0.018790000000000001 6.3462606169165845e-06 0.018800000000000001 1.3413936802271238e-05 0.01881 -2.9225760721705838e-06 0.01882 7.9035326763820891e-06 0.018830000000000003 2.6363528814296591e-06 0.018840000000000003 -9.2927802654699181e-07 0.018850000000000002 -2.5050567717146406e-07 0.018860000000000002 -3.9881093342757619e-06 0.018870000000000001 -2.4169670487084908e-06 0.018880000000000001 -1.6003638601580374e-06 0.018890000000000001 -3.2961189645574487e-06 0.0189 1.2054950540738513e-06 0.018910000000000003 -4.708151876493802e-06 0.018920000000000003 -3.84113454753366e-06 0.018930000000000002 -1.352262742807263e-05 0.018940000000000002 2.2918146765421169e-06 0.018950000000000002 -1.8605166993207976e-06 0.018960000000000001 -1.6424352739458416e-06 0.018970000000000001 -4.7458435083854121e-06 0.01898 -2.9102739671495471e-06 0.01899 -7.9505689327326904e-06 0.019000000000000003 3.6917487528525115e-06 0.019010000000000003 -3.7863261082484533e-06 0.019020000000000002 3.3372864673573517e-06 0.019030000000000002 8.9365432206342807e-06 0.019040000000000001 -3.0488384007588012e-06 0.019050000000000001 5.3973044178576821e-07 0.019060000000000001 6.952838950306159e-06 0.01907 -3.5316387025890206e-07 0.019080000000000003 2.7297788232058751e-07 0.019090000000000003 -1.2948736431940748e-06 0.019100000000000002 -1.2768762644378664e-06 0.019110000000000002 5.7895138104029761e-06 0.019120000000000002 1.6822217090372977e-06 0.019130000000000001 -1.0746848032165702e-05 0.019140000000000001 1.5484669771680342e-06 0.01915 -2.3471554358499687e-06 0.01916 -4.6590355249855799e-06 0.019170000000000003 -4.794529602553741e-06 0.019180000000000003 -2.5213765199463075e-06 0.019190000000000002 2.5730805512127089e-06 0.019200000000000002 1.8172929324803957e-06 0.019210000000000001 -7.0209043050677565e-06 0.019220000000000001 1.2422358493422323e-06 0.019230000000000001 -8.3097981394315383e-07 0.01924 -1.4223029922161873e-06 0.019250000000000003 4.9335279419256667e-07 0.019260000000000003 2.9304456186999809e-06 0.019270000000000002 2.3352548017381839e-06 0.019280000000000002 4.8005748419330321e-06 0.019290000000000002 1.374312503445997e-06 0.019300000000000001 -2.4152342467002715e-08 0.019310000000000001 2.0691959214056178e-06 0.01932 -6.1470237145243736e-06 0.01933 -3.8672047845590166e-07 0.019340000000000003 -4.4136852896996154e-06 0.019350000000000003 -6.1700056947676667e-06 0.019360000000000002 5.7152476553803914e-07 0.019370000000000002 -1.0030314205907842e-05 0.019380000000000001 4.0899652031501255e-06 0.019390000000000001 7.3235365504137435e-06 0.019400000000000001 5.7744307758273721e-06 0.01941 4.7787827179297311e-06 0.019420000000000003 -3.7137465271262706e-06 0.019430000000000003 5.489523998852131e-06 0.019440000000000002 7.9470828011400604e-07 0.019450000000000002 -2.7298781162436509e-06 0.019460000000000002 8.1340836576460457e-06 0.019470000000000001 -4.4948023352431284e-06 0.019480000000000001 -3.3437689880946655e-06 0.01949 6.1571856491421546e-07 0.0195 1.0205701026409685e-05 0.019510000000000003 9.9277065355437904e-07 0.019520000000000003 7.4033390400829212e-06 0.019530000000000002 4.7248027570853002e-06 0.019540000000000002 3.6599015399955141e-06 0.019550000000000001 5.6343396346302357e-06 0.019560000000000001 -1.8259913286631402e-07 0.019570000000000001 2.5625964877847086e-06 0.01958 1.5136500331432207e-06 0.019590000000000003 -2.5421303229964858e-07 0.019600000000000003 -1.79350744588151e-06 0.019610000000000002 8.2436623031966104e-06 0.019620000000000002 3.2206546754965374e-06 0.019630000000000002 -4.3295550520779914e-06 0.019640000000000001 -1.1195949943149714e-06 0.019650000000000001 -1.6910696522654637e-06 0.01966 -3.1241878447517299e-06 0.01967 -2.4090456614862677e-06 0.019680000000000003 -1.9996302625029226e-06 0.019690000000000003 -4.2859919848893319e-06 0.019700000000000002 -2.6625648174828074e-06 0.019710000000000002 -3.4898149378249964e-06 0.019720000000000001 4.8758417066932298e-06 0.019730000000000001 4.2026753068946392e-06 0.019740000000000001 -5.272143811624296e-06 0.01975 6.8716845849504173e-06 0.019760000000000003 5.5072879978996711e-06 0.019770000000000003 4.9755497288582432e-08 0.019780000000000002 -4.5652849380127016e-06 0.019790000000000002 -3.4602367189735542e-06 0.019800000000000002 8.5119675586232793e-06 0.019810000000000001 -6.2256244437511658e-06 0.019820000000000001 -4.8686533017668829e-07 0.01983 6.5232542746601942e-07 0.01984 2.1153113861665054e-06 0.019850000000000003 -7.4994899466606803e-07 0.019860000000000003 6.1916351522816319e-07 0.019870000000000002 3.7669045043517272e-06 0.019880000000000002 1.8203278212225611e-06 0.019890000000000001 -7.4151067078561403e-07 0.019900000000000001 -1.3880730893345873e-06 0.019910000000000001 1.1263474954301315e-06 0.01992 3.9971002291205465e-06 0.019930000000000003 -1.0883135711465334e-05 0.019940000000000003 -7.6945653687036486e-06 0.019950000000000002 -4.0655854115480545e-07 0.019960000000000002 -4.356237984223264e-06 0.019970000000000002 8.3877964518613812e-06 0.019980000000000001 6.4635904316935571e-07 0.019990000000000001 1.6787501507770771e-06 0.02 -1.1553400658568501e-05 0.02001 -2.934474625698115e-06 0.020020000000000003 -1.1357722554471775e-06 0.020030000000000003 7.7426208773163952e-06 0.020040000000000002 4.4212605130679673e-06 0.020050000000000002 -8.59498541430186e-07 0.020060000000000001 2.8984664217750681e-06 0.020070000000000001 -6.4725581546926698e-06 0.020080000000000001 5.8569303695584608e-06 0.02009 -6.7509472970644693e-06 0.020100000000000003 8.430209779927564e-06 0.020110000000000003 -7.3099419425497235e-06 0.020120000000000002 -3.6356792087595261e-06 0.020130000000000002 -3.1442219880898334e-06 0.020140000000000002 -7.3452175507729971e-06 0.020150000000000001 8.6614193301110623e-06 0.020160000000000001 -6.1536034193193683e-06 0.02017 -1.4773305660047626e-06 0.02018 -4.7070839606587266e-07 0.020190000000000003 -1.5886416054294584e-06 0.020200000000000003 4.7635596205074245e-06 0.020210000000000002 -5.0394606187360052e-07 0.020220000000000002 -7.0980050476548308e-06 0.020230000000000001 -1.8223628543912912e-06 0.020240000000000001 2.421408835403813e-06 0.020250000000000001 -5.3402294404201158e-06 0.02026 -4.1941490244597171e-06 0.020270000000000003 -1.1640124346106648e-06 0.020280000000000003 2.2716633842266461e-06 0.020290000000000002 3.5488234956466876e-06 0.020300000000000002 9.1048872998267029e-06 0.020310000000000002 1.4518948529781265e-05 0.020320000000000001 6.8363141831345516e-06 0.020330000000000001 8.7516792572558226e-06 0.02034 -3.5927692934515173e-06 0.02035 3.3623414090490527e-06 0.020360000000000003 -5.7326540431891471e-06 0.020370000000000003 -2.9427285429091435e-06 0.020380000000000002 2.8210422194657679e-06 0.020390000000000002 6.2677034090522112e-06 0.020400000000000001 -3.4143242263437625e-06 0.020410000000000001 6.1792175841967407e-06 0.020420000000000001 1.8806454387155649e-06 0.02043 6.290615795481906e-06 0.020440000000000003 6.8494413111862605e-06 0.020450000000000003 -7.6687492993122707e-06 0.020460000000000002 -2.7190389241919968e-06 0.020470000000000002 1.3934848630609033e-06 0.020480000000000002 -6.7664516445790672e-06 0.020490000000000001 8.116577999113937e-07 0.020500000000000001 -2.2574940725688406e-07 0.02051 9.3538381015491037e-06 0.02052 -7.7424468730941366e-06 0.020530000000000003 2.8907360116940474e-06 0.020540000000000003 7.5631477901416794e-06 0.020550000000000002 2.3700404995159276e-06 0.020560000000000002 -1.2969624583883984e-05 0.020570000000000001 -3.4118715344891496e-07 0.020580000000000001 -4.5235348975317239e-06 0.020590000000000001 4.8993209032147499e-06 0.0206 3.8512242948665654e-06 0.020610000000000003 1.4829536315069821e-06 0.020620000000000003 1.600351793864037e-06 0.020630000000000003 1.9618147938385222e-06 0.020640000000000002 -4.0312556003329031e-06 0.020650000000000002 -1.8860314260115735e-06 0.020660000000000001 4.4266991361600754e-06 0.020670000000000001 1.2507730288399972e-06 0.02068 7.8030416400166493e-09 0.02069 -8.8561492684528664e-06 0.020700000000000003 6.0005104873802831e-06 0.020710000000000003 -7.6734651034606492e-06 0.020720000000000002 3.4229724827952877e-07 0.020730000000000002 -3.704779125623097e-06 0.020740000000000001 3.1092061570067255e-06 0.020750000000000001 2.1499724344563151e-07 0.020760000000000001 3.3611913409458902e-06 0.02077 -1.1640507330418929e-07 0.020780000000000003 2.6077756939847589e-06 0.020790000000000003 -1.58842722173066e-06 0.020800000000000003 7.5358307853801985e-06 0.020810000000000002 -1.0014670236980394e-06 0.020820000000000002 4.949814602478357e-07 0.020830000000000001 5.0262727076989723e-06 0.020840000000000001 5.0885314240542043e-07 0.02085 3.4431685484986205e-06 0.02086 1.5560079055630891e-06 0.020870000000000003 -1.3245737589899317e-07 0.020880000000000003 2.429607407434751e-06 0.020890000000000002 7.5852097380383572e-07 0.020900000000000002 4.7956200876060944e-06 0.020910000000000002 1.9776975610420938e-06 0.020920000000000001 -3.3645600885507472e-06 0.020930000000000001 4.8855395648086971e-06 0.02094 -2.5295205918531911e-07 0.020950000000000003 1.8390029863174111e-06 0.020960000000000003 -3.5424423240496077e-06 0.020970000000000003 -8.717237968228952e-06 0.020980000000000002 -5.5476812525542973e-07 0.020990000000000002 6.8351682312770499e-06 0.021000000000000001 2.8008647000679655e-06 0.021010000000000001 -1.0624925123498136e-07 0.02102 8.6432413856791677e-07 0.02103 -1.6482401301870899e-07 0.021040000000000003 -4.654874404736136e-06 0.021050000000000003 4.9310646705048402e-06 0.021060000000000002 3.5635680420548335e-06 0.021070000000000002 3.8064248444318077e-06 0.021080000000000002 1.1602646110557219e-05 0.021090000000000001 1.8060419731444905e-06 0.021100000000000001 4.8991204733500993e-06 0.02111 1.671536548099036e-06 0.021120000000000003 1.3225009658182309e-06 0.021130000000000003 -2.8992061696810005e-06 0.021140000000000003 -3.6532945981401085e-06 0.021150000000000002 -3.1019688947811267e-09 0.021160000000000002 -6.1717197125323486e-07 0.021170000000000001 6.692409864142104e-06 0.021180000000000001 -1.1799461732405819e-06 0.021190000000000001 2.8624695787956292e-06 0.0212 6.601578111908461e-06 0.021210000000000003 3.7516986642825141e-06 0.021220000000000003 -2.693112605617581e-06 0.021230000000000002 -3.8678317533305935e-06 0.021240000000000002 2.6381349443464364e-06 0.021250000000000002 5.1495931901180339e-06 0.021260000000000001 -4.7967773696089285e-06 0.021270000000000001 -5.9636966222107003e-06 0.02128 -3.4564902135599593e-06 0.021290000000000003 -5.9664582938724996e-07 0.021300000000000003 -3.5217891708028327e-07 0.021310000000000003 -2.2997282055161068e-06 0.021320000000000002 3.173899532983754e-06 0.021330000000000002 -1.3725516896812367e-05 0.021340000000000001 -1.2316007877849115e-05 0.021350000000000001 6.8538856177785431e-06 0.021360000000000001 -2.766263644692695e-06 0.02137 -1.6422311491200493e-06 0.021380000000000003 1.9232232274998059e-06 0.021390000000000003 -3.7109259445426775e-06 0.021400000000000002 -2.186787514805864e-07 0.021410000000000002 1.018116726124774e-06 0.021420000000000002 5.124313397331757e-06 0.021430000000000001 8.7296067999446103e-06 0.021440000000000001 -1.5500307778700488e-07 0.02145 6.6695030460134726e-06 0.021460000000000003 2.6786281321773311e-06 0.021470000000000003 -7.9941818777249389e-06 0.021480000000000003 -5.3779911776084006e-06 0.021490000000000002 2.5893873363734267e-06 0.021500000000000002 4.6579871230674197e-06 0.021510000000000001 1.4349719165741253e-07 0.021520000000000001 9.0671597930180642e-06 0.021530000000000001 1.3017589187879204e-06 0.02154 1.0636281272174e-05 0.021550000000000003 5.5568409515951024e-06 0.021560000000000003 -7.3811037812524374e-06 0.021570000000000002 1.23071788799084e-06 0.021580000000000002 -3.6085090729767217e-07 0.021590000000000002 -3.4366186687106155e-06 0.021600000000000001 -7.8676529962360268e-06 0.021610000000000001 3.7706948817353035e-06 0.02162 -8.6204113684544201e-07 0.021630000000000003 -5.7228967519548582e-06 0.021640000000000003 8.7478190592168427e-07 0.021650000000000003 -2.3511189719258042e-06 0.021660000000000002 9.8570910569553115e-06 0.021670000000000002 2.6089488557404415e-06 0.021680000000000001 -4.7395307192876137e-06 0.021690000000000001 -1.5215579046324155e-06 0.021700000000000001 2.2440366588658733e-06 0.02171 8.1899294546461951e-06 0.021720000000000003 5.1849084971560158e-06 0.021730000000000003 2.5339992328892529e-06 0.021740000000000002 5.6759714590405698e-06 0.021750000000000002 -1.0270121445239026e-05 0.021760000000000002 -2.390524325507337e-06 0.021770000000000001 -3.6745368699193653e-06 0.021780000000000001 -4.0293914732973676e-06 0.02179 -2.6814812298769921e-06 0.021800000000000003 3.3303219877449781e-06 0.021810000000000003 3.5149785553161843e-06 0.021820000000000003 2.0612216103645478e-06 0.021830000000000002 -6.5092531029031489e-06 0.021840000000000002 2.0270020487582923e-06 0.021850000000000001 -1.0740531454491009e-06 0.021860000000000001 2.211694483630674e-06 0.021870000000000001 -5.1233900186395896e-07 0.02188 -2.4432023338370677e-06 0.021890000000000003 2.7711461033857774e-06 0.021900000000000003 -1.249534266490865e-06 0.021910000000000002 -2.4942161730427505e-06 0.021920000000000002 -4.7312079142677753e-06 0.021930000000000002 -2.7210741757408033e-06 0.021940000000000001 4.4311773792904036e-07 0.021950000000000001 -1.7167038595736485e-06 0.02196 1.9753804461161123e-06 0.021970000000000003 5.3447452100504715e-06 0.021980000000000003 1.2024955565870354e-06 0.021990000000000003 5.4124938186955247e-07 0.022000000000000002 -3.5764299377370943e-06 0.022010000000000002 8.8073430994234776e-06 0.022020000000000001 2.5861652202192155e-06 0.022030000000000001 -3.3762504748772328e-07 0.022040000000000001 4.1136528796743932e-06 0.02205 -1.0414385763131844e-06 0.022060000000000003 4.1097461449527828e-06 0.022070000000000003 -4.1796012539993989e-06 0.022080000000000002 1.1729738899452834e-05 0.022090000000000002 -3.0527165970155961e-07 0.022100000000000002 -3.1912534148658308e-06 0.022110000000000001 -3.6550584003173174e-06 0.022120000000000001 -2.2467578101548807e-06 0.02213 1.4758651731970092e-06 0.022140000000000003 2.7822293088202055e-06 0.022150000000000003 4.7424189818118998e-07 0.022160000000000003 -3.2971827122878565e-06 0.022170000000000002 -1.4442365582436708e-06 0.022180000000000002 7.6411971377557947e-06 0.022190000000000001 -4.4383338116534117e-06 0.022200000000000001 4.5593543572766743e-06 0.022210000000000001 1.4573693538007644e-05 0.02222 3.752035571910437e-06 0.022230000000000003 2.0607053605200138e-06 0.022240000000000003 2.5605601952695232e-06 0.022250000000000002 2.4014959527028751e-06 0.022260000000000002 -7.5768854817300734e-06 0.022270000000000002 1.1203385412483791e-05 0.022280000000000001 2.156422353488848e-06 0.022290000000000001 -6.1521776526780185e-06 0.0223 -2.2641416645938336e-06 0.022310000000000003 -2.3224274940973508e-06 0.022320000000000003 -5.1744744293098333e-06 0.022330000000000003 6.9283367159456391e-06 0.022340000000000002 -6.3433911272583592e-06 0.022350000000000002 5.4198083331022367e-06 0.022360000000000001 -4.3942589532348357e-06 0.022370000000000001 3.7708447390835519e-06 0.022380000000000001 -9.670205393596632e-07 0.02239 -4.0220058056458774e-06 0.022400000000000003 6.052307802889071e-06 0.022410000000000003 2.7465487846124652e-06 0.022420000000000002 -5.9200929832978667e-06 0.022430000000000002 -1.3767137798768957e-06 0.022440000000000002 6.1787991425666105e-06 0.022450000000000001 -8.5270177259487689e-06 0.022460000000000001 -5.6810453451053158e-06 0.02247 7.1016887974042601e-06 0.022480000000000003 -2.1953892647429591e-06 0.022490000000000003 3.6402324376493297e-06 0.022500000000000003 4.7852008473725468e-06 0.022510000000000002 -4.9452041660761472e-06 0.022520000000000002 6.9412958529349547e-06 0.022530000000000001 -6.9987212667711535e-06 0.022540000000000001 3.477700211554238e-06 0.022550000000000001 -7.4174506903713513e-06 0.02256 -4.8491906415710242e-06 0.022570000000000003 4.0257146536746464e-06 0.022580000000000003 -1.8670915602738396e-07 0.022590000000000002 -7.6569534677779494e-06 0.022600000000000002 -3.9899375115560262e-06 0.022610000000000002 -2.3120251317700743e-06 0.022620000000000001 2.0462247036988593e-06 0.022630000000000001 -4.2877143864228591e-06 0.02264 1.7619758160114633e-06 0.022650000000000003 -4.8138712297782661e-06 0.022660000000000003 1.3155837150785173e-06 0.022670000000000003 4.3410980784693942e-06 0.022680000000000002 4.1792022988993121e-07 0.022690000000000002 -7.0788766905416971e-06 0.022700000000000001 3.4344408047556841e-06 0.022710000000000001 5.2700784727674673e-06 0.022720000000000001 1.2941702832894734e-06 0.02273 -3.7589593949242394e-06 0.022740000000000003 -6.519981000801294e-06 0.022750000000000003 -4.5771102546470433e-06 0.022760000000000002 -2.2928827790655934e-06 0.022770000000000002 -9.7735499565660993e-06 0.022780000000000002 -3.9960593236796877e-06 0.022790000000000001 -1.9998053094258217e-06 0.022800000000000001 3.1083429996751985e-06 0.02281 -6.4030041449588321e-06 0.022820000000000003 8.8313367854401551e-06 0.022830000000000003 1.6386454609342962e-06 0.022840000000000003 -4.3221331022096768e-06 0.022850000000000002 3.5620816952720788e-06 0.022860000000000002 1.7374757634273003e-06 0.022870000000000001 -3.3849803629507398e-06 0.022880000000000001 -6.6727701075526602e-07 0.022890000000000001 5.1263065289131264e-06 0.0229 -2.533248937022964e-06 0.022910000000000003 -2.6378782510145929e-06 0.022920000000000003 6.6902059673223656e-06 0.022930000000000002 4.0417145211068323e-06 0.022940000000000002 1.1076800343507346e-05 0.022950000000000002 -4.3540172077569768e-06 0.022960000000000001 2.0283270995668368e-06 0.022970000000000001 4.2178749059047945e-06 0.02298 6.9176045067866459e-07 0.022990000000000003 -6.0368837361399028e-06 0.023000000000000003 -3.3109706268876364e-06 0.023010000000000003 7.7209089628009823e-07 0.023020000000000002 -4.7303979398651272e-06 0.023030000000000002 3.6311568652490775e-07 0.023040000000000001 6.3773781961932525e-06 0.023050000000000001 4.0993435989085325e-06 0.023060000000000001 -4.2199314994052647e-06 0.02307 8.0526397923991136e-06 0.023080000000000003 1.5639552604550211e-06 0.023090000000000003 -2.7941987318305908e-06 0.023100000000000002 -1.0643068343562425e-06 0.023110000000000002 2.7056849551063483e-07 0.023120000000000002 -2.0219544167899269e-06 0.023130000000000001 -8.1576510241462477e-07 0.023140000000000001 5.5750000171166216e-06 0.02315 -4.4553703024700218e-06 0.023160000000000004 -5.3126146741473764e-06 0.023170000000000003 -1.6772724997721721e-06 0.023180000000000003 -3.2885987381084922e-06 0.023190000000000002 -1.0010834825948971e-06 0.023200000000000002 -7.3534999831826953e-07 0.023210000000000001 -4.5372570438278653e-06 0.023220000000000001 2.0123128038933511e-07 0.023230000000000001 -6.2534723090823233e-07 0.02324 -5.0568984628267757e-06 0.023250000000000003 -3.6001751825367532e-06 0.023260000000000003 -4.1870538791795763e-06 0.023270000000000002 1.7559054907293564e-06 0.023280000000000002 -7.7741964083082257e-06 0.023290000000000002 4.5244696722322206e-06 0.023300000000000001 -1.1299087604384308e-06 0.023310000000000001 3.2669095471622814e-06 0.02332 4.4420406326563616e-06 0.023330000000000004 -6.8359304528808721e-07 0.023340000000000003 -2.5376413436168706e-06 0.023350000000000003 -3.8514436200432778e-06 0.023360000000000002 -6.3056780727794894e-06 0.023370000000000002 -5.8472029885009259e-06 0.023380000000000001 3.5196465917578915e-06 0.023390000000000001 -1.6325780287615275e-06 0.023400000000000001 1.4251867964057947e-06 0.02341 5.1582459124663464e-06 0.023420000000000003 1.1879267652082582e-06 0.023430000000000003 -1.7333693927475156e-06 0.023440000000000003 -3.7871854542464153e-06 0.023450000000000002 -9.5516265391032397e-06 0.023460000000000002 -4.4570805298659583e-06 0.023470000000000001 1.1160424443500105e-06 0.023480000000000001 3.5461147696501434e-06 0.02349 -2.4033755516370359e-07 0.023500000000000004 -5.8059250764538035e-06 0.023510000000000003 -6.944752810186435e-06 0.023520000000000003 -4.9406126326674728e-06 0.023530000000000002 -2.4347411234444716e-06 0.023540000000000002 1.2437070939574008e-06 0.023550000000000001 1.860451739014336e-06 0.023560000000000001 3.017322904512028e-06 0.023570000000000001 -4.9402046789778072e-06 0.02358 1.8755072299446947e-06 0.023590000000000003 -5.2511084119001687e-06 0.023600000000000003 -9.6859998508552722e-07 0.023610000000000003 -8.9183326429296486e-06 0.023620000000000002 2.2647620212049605e-06 0.023630000000000002 7.8547635726319435e-06 0.023640000000000001 1.0966308140683505e-06 0.023650000000000001 -4.3217348133619673e-06 0.02366 -2.8772621827746415e-06 0.023670000000000004 -3.9082214786178134e-06 0.023680000000000003 4.1848690228067599e-06 0.023690000000000003 2.6119035372373496e-06 0.023700000000000002 -1.1488119988325901e-05 0.023710000000000002 3.2415393689579539e-06 0.023720000000000001 -1.0016300447604783e-06 0.023730000000000001 -3.9274715535900166e-06 0.023740000000000001 -2.0079979059605993e-06 0.02375 4.8227905646003006e-06 0.023760000000000003 -2.0244253267755029e-06 0.023770000000000003 -1.0676858271722768e-05 0.023780000000000003 -6.9386246758874887e-06 0.023790000000000002 -2.2087567715859074e-06 0.023800000000000002 -7.3601194610562077e-06 0.023810000000000001 2.4230612952981514e-06 0.023820000000000001 -3.1999055514955973e-06 0.02383 -4.1222499071861118e-06 0.023840000000000004 1.0075801564916925e-05 0.023850000000000003 1.0603812103104942e-06 0.023860000000000003 -2.026395488508481e-06 0.023870000000000002 5.8641561649729464e-06 0.023880000000000002 -2.3256523131599962e-06 0.023890000000000002 3.7414644060789756e-06 0.023900000000000001 -1.6303356268942594e-06 0.023910000000000001 -7.1659246400731327e-06 0.02392 1.340225672451004e-06 0.023930000000000003 7.2428731415113263e-06 0.023940000000000003 1.5356814805238532e-05 0.023950000000000003 4.658962852642954e-06 0.023960000000000002 -8.5482943532458811e-06 0.023970000000000002 1.0455293672053607e-05 0.023980000000000001 7.8800093486531035e-06 0.023990000000000001 -2.1069181484338353e-06 0.024 2.9887385564391942e-06)
Vtargetnoise targetnoise 0 PWL(0 4.0355524133677106e-06 1.0000000000000001e-05 1.2366524925293908e-05 2.0000000000000002e-05 8.0950154749193683e-06 3.0000000000000004e-05 -1.7908962196216007e-06 4.0000000000000003e-05 1.1350914240046747e-06 5.0000000000000002e-05 -4.2159211980656643e-06 6.0000000000000008e-05 -3.9477276988655807e-07 7.0000000000000007e-05 4.505297827252363e-06 8.0000000000000007e-05 5.7078744979423396e-06 9.0000000000000006e-05 3.810746634550373e-06 0.0001 -2.0879192516434969e-06 0.00011 3.1666608612022354e-06 0.00012000000000000002 9.3051233190073188e-06 0.00013000000000000002 -4.3083954790512941e-06 0.00014000000000000001 -3.7943448613919946e-07 0.00015000000000000001 9.5303491433337396e-06 0.00016000000000000001 1.7759104865349499e-06 0.00017000000000000001 -1.740282242342808e-06 0.00018000000000000001 -4.430550607421363e-06 0.00019000000000000001 3.2526533685005635e-06 0.00020000000000000001 -5.484737545740445e-07 0.00021000000000000001 1.077057711240367e-06 0.00022000000000000001 3.4741269118052325e-06 0.00023000000000000001 3.5274405323946252e-07 0.00024000000000000003 -3.567798294962428e-06 0.00025000000000000001 3.0061208132896881e-06 0.00026000000000000003 4.0509973923030325e-06 0.00027 -2.1953688807989252e-06 0.00028000000000000003 3.7818263567473472e-06 0.00029 6.4793021244454271e-06 0.00030000000000000003 7.0664040950701309e-06 0.00031 9.7645489904406794e-06 0.00032000000000000003 -1.0379326306618436e-05 0.00033000000000000005 -1.7563894734738668e-07 0.00034000000000000002 -2.2527663158851924e-06 0.00035000000000000005 -4.4863762385564248e-06 0.00036000000000000002 3.3242100769906614e-06 0.00037000000000000005 1.2436018308171564e-05 0.00038000000000000002 -7.9010912378780224e-06 0.00039000000000000005 -5.8002885338483196e-06 0.00040000000000000002 -5.5491386019524721e-06 0.00041000000000000005 -5.0252487660587348e-06 0.00042000000000000002 2.9569205884284167e-06 0.00043000000000000004 -1.317647987310823e-06 0.00044000000000000002 -5.6194203406714344e-07 0.00045000000000000004 6.391680172669803e-06 0.00046000000000000001 -8.0791398724034021e-06 0.00047000000000000004 -1.0943389406640244e-05 0.00048000000000000007 5.817547329024884e-06 0.00049000000000000009 4.1396247637744094e-08 0.00050000000000000001 1.7645657662909235e-06 0.00051000000000000004 2.8377186958107915e-06 0.00052000000000000006 9.7218473406402485e-06 0.00053000000000000009 -5.8832496602128907e-06 0.00054000000000000001 1.8028630319058623e-06 0.00055000000000000003 -8.6575593723390357e-07 0.00056000000000000006 2.6754389938603997e-06 0.00057000000000000009 4.0845325266621977e-06 0.00058 2.01185592719821e-06 0.00059000000000000003 1.0216259653469405e-05 0.00060000000000000006 -2.8262086999482297e-06 0.00061000000000000008 -5.0043290098415452e-06 0.00062 -1.176164096044555e-06 0.00063000000000000003 -4.0356996986672203e-06 0.00064000000000000005 -1.9306414815208772e-06 0.00065000000000000008 3.0617942128792831e-06 0.0006600000000000001 -9.4817135022399895e-07 0.00067000000000000002 -2.1826503699179628e-06 0.00068000000000000005 -2.1900133967272732e-06 0.00069000000000000008 1.9301945424493027e-07 0.0007000000000000001 8.1371387216491903e-06 0.00071000000000000002 -5.9848096284652401e-06 0.00072000000000000005 3.4119439931467401e-06 0.00073000000000000007 4.5964276827537882e-06 0.0007400000000000001 -2.0754548870637077e-06 0.00075000000000000002 -5.9950594097023555e-06 0.00076000000000000004 -4.3200672366011229e-06 0.00077000000000000007 -8.1780907541674006e-06 0.00078000000000000009 4.4307511623794416e-06 0.00079000000000000001 8.6427867723871757e-07 0.00080000000000000004 1.1986762200931213e-06 0.00081000000000000006 -7.2127547005146405e-06 0.00082000000000000009 1.0207577190058693e-05 0.00083000000000000012 1.5921690098183275e-06 0.00084000000000000003 -2.3437591083782301e-06 0.00085000000000000006 4.4076595890178978e-06 0.00086000000000000009 1.6800513038678997e-06 0.00087000000000000011 -2.1823886691751549e-06 0.00088000000000000003 -1.0498541121093458e-05 0.00089000000000000006 -6.2442247870844726e-06 0.00090000000000000008 6.1448179530849009e-06 0.00091000000000000011 7.1663562626173723e-06 0.00092000000000000003 -5.1055099239178163e-06 0.00093000000000000005 5.232375667555707e-06 0.00094000000000000008 -1.5656266678510095e-06 0.00095000000000000011 -4.5418716359705467e-06 0.00096000000000000013 -2.1261902438388412e-06 0.00097000000000000005 -9.9282058349937427e-07 0.00098000000000000019 -1.920096231770105e-06 0.00098999999999999999 -1.4496399020833882e-06 0.001 -7.7354339393663397e-08 0.00101 1.7770329312027814e-06 0.0010200000000000001 -3.3449722093816024e-06 0.0010300000000000001 -8.5212242729114284e-06 0.0010400000000000001 9.0657246680970621e-07 0.0010500000000000002 1.3304876293870914e-06 0.0010600000000000002 -3.4170706375387102e-07 0.00107 -6.7503346432167227e-06 0.00108 8.7695845661579157e-07 0.00109 4.5132664566521272e-06 0.0011000000000000001 9.947214426650702e-07 0.0011100000000000001 -4.126912963570591e-06 0.0011200000000000001 -2.3278608040758678e-06 0.0011300000000000001 5.4552023684133616e-07 0.0011400000000000002 -5.6789587931166831e-06 0.0011500000000000002 3.3777320794705665e-06 0.00116 -3.891723212772031e-06 0.00117 -5.1735112240512334e-06 0.0011800000000000001 -2.3361138578394681e-07 0.0011900000000000001 -5.3627507723586755e-06 0.0012000000000000001 -2.0634961618194902e-06 0.0012100000000000001 5.3937242634493723e-06 0.0012200000000000002 -6.1252200289464615e-06 0.0012300000000000002 -3.9770245963728191e-06 0.00124 -3.9146577415487409e-06 0.00125 1.4414207082794475e-07 0.0012600000000000001 8.5463575163979315e-06 0.0012700000000000001 -7.8198737792957741e-07 0.0012800000000000001 2.4507382359260655e-07 0.0012900000000000001 6.1631989692896866e-06 0.0013000000000000002 -3.9121992178749499e-06 0.0013100000000000002 -1.7363801196950509e-06 0.0013200000000000002 -4.1313658891250316e-06 0.00133 1.267457148455726e-05 0.00134 1.1635407646117003e-05 0.0013500000000000001 -8.214345947663321e-06 0.0013600000000000001 4.0146444649699061e-06 0.0013700000000000001 -8.4438316405245259e-06 0.0013800000000000002 -1.4559113093781656e-06 0.0013900000000000002 -4.791712456065134e-06 0.0014000000000000002 -1.4547447392233166e-06 0.00141 1.5841044224004005e-06 0.00142 -1.0685419713369198e-05 0.0014300000000000001 -8.0182767402333301e-07 0.0014400000000000001 -1.6736426340614521e-06 0.0014500000000000001 -4.9462791774356178e-07 0.0014600000000000001 3.9927812382592048e-06 0.0014700000000000002 3.1012097708561052e-06 0.0014800000000000002 1.4390261545091165e-06 0.0014900000000000002 -3.2983264111255193e-06 0.0015 2.196029855799708e-07 0.0015100000000000001 4.0696244791070018e-06 0.0015200000000000001 1.1732323710169563e-05 0.0015300000000000001 9.9862193451152596e-07 0.0015400000000000001 -4.5600250131254595e-06 0.0015500000000000002 1.0159293799959414e-06 0.0015600000000000002 2.8980398902751062e-06 0.0015700000000000002 9.2474507009087938e-06 0.00158 -3.1515544348653006e-06 0.0015900000000000001 -2.3932433871301764e-06 0.0016000000000000001 -6.3274181229907847e-06 0.0016100000000000001 3.3447643700771087e-06 0.0016200000000000001 -3.2049517408357654e-06 0.0016300000000000002 -8.1928450149428084e-06 0.0016400000000000002 3.9627313043379215e-06 0.0016500000000000002 -6.0568699048182013e-06 0.0016600000000000002 7.5299100174209202e-06 0.00167 8.9173774132897751e-07 0.0016800000000000001 4.2116777081375758e-06 0.0016900000000000001 2.0049155911235575e-06 0.0017000000000000001 5.043664167610398e-06 0.0017100000000000001 3.097332143876955e-06 0.0017200000000000002 1.7877345506214711e-06 0.0017300000000000002 4.187954743750767e-06 0.0017400000000000002 1.4072323410256936e-05 0.00175 3.4184238447100028e-06 0.0017600000000000001 4.1418856273050231e-06 0.0017700000000000001 9.5077486315420854e-06 0.0017800000000000001 6.1077637479173334e-06 0.0017900000000000001 -4.6182795088340328e-06 0.0018000000000000002 3.258506329421267e-06 0.0018100000000000002 -5.6732930936883809e-06 0.0018200000000000002 -1.407357224908192e-06 0.0018300000000000002 -4.2999909133091601e-06 0.0018400000000000001 -3.6863472297346858e-06 0.0018500000000000001 -5.1597949706719905e-06 0.0018600000000000001 -1.3658970822787489e-06 0.0018700000000000001 3.4115458702386078e-07 0.0018800000000000002 2.141217356141572e-06 0.0018900000000000002 -6.3898467835141594e-06 0.0019000000000000002 -7.1414279618828991e-07 0.0019100000000000002 -5.6197987338419155e-06 0.0019200000000000003 5.379387398974303e-06 0.0019300000000000001 1.4322207322492503e-06 0.0019400000000000001 4.1123697694942434e-06 0.0019500000000000001 4.2381057669174689e-06 0.0019600000000000004 5.5815651824047597e-07 0.00197 -1.0638208093200549e-06 0.00198 4.1915991241443628e-06 0.00199 8.1535936990260406e-06 0.002 5.0701485481968194e-06 0.0020100000000000001 1.2206720875734368e-05 0.0020200000000000001 3.1939908078136108e-06 0.0020300000000000001 9.3787803868376763e-06 0.0020400000000000001 2.1546157068546496e-06 0.0020500000000000002 5.0890961401924199e-07 0.0020600000000000002 2.6059081073479541e-06 0.0020700000000000002 -1.341606694400607e-05 0.0020800000000000003 4.8320756114220515e-06 0.0020900000000000003 4.5267710359988065e-06 0.0021000000000000003 -3.8982966378835684e-07 0.0021100000000000003 2.7048258344939992e-06 0.0021200000000000004 1.1194633796363692e-05 0.0021300000000000004 -4.5372900139872599e-06 0.00214 -5.3678239973054428e-06 0.00215 -3.8008108152830768e-06 0.00216 -1.2790742429654163e-06 0.0021700000000000001 8.859445855189612e-06 0.0021800000000000001 3.9662719125439565e-07 0.0021900000000000001 4.9516034356879111e-06 0.0022000000000000001 7.1364722186758601e-07 0.0022100000000000002 1.5127067950527006e-07 0.0022200000000000002 -7.9369439044376943e-06 0.0022300000000000002 -9.2211428311384087e-07 0.0022400000000000002 2.8478258769419433e-06 0.0022500000000000003 -9.3276339388572519e-06 0.0022600000000000003 -7.0370312588198538e-07 0.0022700000000000003 5.2302003729641712e-06 0.0022800000000000003 5.1724590854678194e-06 0.0022900000000000004 -3.2397164269751092e-07 0.0023000000000000004 5.1281660413092859e-06 0.00231 -2.0260010893844583e-06 0.00232 -1.7963382623619539e-06 0.00233 -4.9414450954611633e-06 0.0023400000000000001 1.1222783014054136e-05 0.0023500000000000001 -4.1874154698905213e-06 0.0023600000000000001 5.2730166457613889e-06 0.0023700000000000001 -1.3855656131905653e-06 0.0023800000000000002 4.9606393545600766e-06 0.0023900000000000002 -1.675942389629256e-06 0.0024000000000000002 1.0075230091621948e-05 0.0024100000000000002 3.4642729540471687e-06 0.0024200000000000003 -7.3245869673688117e-06 0.0024300000000000003 -9.3126048324063456e-06 0.0024400000000000003 -6.6435988594193326e-06 0.0024500000000000004 4.7706442609834228e-06 0.0024600000000000004 -3.7703873653508277e-06 0.0024700000000000004 7.1157013085244129e-06 0.00248 7.8257049537604223e-07 0.00249 7.2122949774229524e-07 0.0025000000000000001 2.2649271145015876e-07 0.0025100000000000001 -6.2799557058622276e-06 0.0025200000000000001 -5.2472923526945864e-06 0.0025300000000000001 1.3431079432992349e-06 0.0025400000000000002 2.5775927537000422e-06 0.0025500000000000002 -2.4612946707413952e-06 0.0025600000000000002 -2.4177052601362005e-06 0.0025700000000000002 7.4952773025134844e-07 0.0025800000000000003 2.5996157107458376e-06 0.0025900000000000003 -8.8558928812064822e-06 0.0026000000000000003 5.6962681310949445e-06 0.0026100000000000003 -4.3958916813992061e-06 0.0026200000000000004 2.8769072424360976e-06 0.0026300000000000004 -3.9041049632253429e-06 0.0026400000000000004 -8.4390668826541883e-06 0.00265 -4.6320470120486897e-06 0.00266 -4.9602625529767902e-06 0.0026700000000000001 8.8845235974201539e-07 0.0026800000000000001 1.1576392960965183e-06 0.0026900000000000001 -2.0694242173609742e-06 0.0027000000000000001 -8.3551387314156872e-06 0.0027100000000000002 -2.2729127525838361e-06 0.0027200000000000002 -7.1686153090492815e-07 0.0027300000000000002 7.7390465721280679e-06 0.0027400000000000002 -4.1301207758786706e-06 0.0027500000000000003 -6.3366241779400215e-06 0.0027600000000000003 -8.8588795827999793e-06 0.0027700000000000003 -3.2303388867200492e-06 0.0027800000000000004 -3.9251008451560997e-07 0.0027900000000000004 2.0518722624379545e-07 0.0028000000000000004 1.8171730719802354e-06 0.0028100000000000004 6.8190735686207256e-06 0.00282 -8.8392997072924594e-06 0.0028300000000000001 -3.3994325581447503e-07 0.0028400000000000001 1.1705547461882019e-07 0.0028500000000000001 -7.1448390399009318e-06 0.0028600000000000001 2.8736149552844523e-06 0.0028700000000000002 -1.9359008246774292e-05 0.0028800000000000002 -7.8792294617174258e-06 0.0028900000000000002 -2.6797867368237339e-06 0.0029000000000000002 -3.5075290602401074e-06 0.0029100000000000003 2.3403571400912128e-06 0.0029200000000000003 -2.4151147704345791e-06 0.0029300000000000003 -2.189382261579114e-06 0.0029400000000000003 -4.3614021975784862e-07 0.0029500000000000004 -3.826736052554594e-06 0.0029600000000000004 1.3698889899296347e-06 0.0029700000000000004 -9.660881052200599e-07 0.0029800000000000004 3.5965301978113396e-07 0.00299 -1.0557042982573622e-05 0.0030000000000000001 8.753839555185925e-06 0.0030100000000000001 -8.0820047650290917e-07 0.0030200000000000001 -8.615963563806808e-07 0.0030300000000000001 -1.0361110138656689e-06 0.0030400000000000002 8.232518126015768e-07 0.0030500000000000002 -1.6856609019314592e-06 0.0030600000000000002 1.134965896517302e-06 0.0030700000000000002 -8.1660075703259037e-07 0.0030800000000000003 -1.6837646827371841e-07 0.0030900000000000003 1.0606991226209655e-05 0.0031000000000000003 5.2424644814958222e-06 0.0031100000000000004 -1.0724428613417107e-06 0.0031200000000000004 2.6101500760049668e-06 0.0031300000000000004 -5.3330602237629256e-07 0.0031400000000000004 -1.7073500570318486e-06 0.0031500000000000005 4.342310011851578e-06 0.00316 -4.0227181211240154e-06 0.0031700000000000001 -2.2634679079406828e-06 0.0031800000000000001 7.5481582437763182e-07 0.0031900000000000001 5.3105030389341804e-06 0.0032000000000000002 3.3440965908693311e-06 0.0032100000000000002 -1.0983930088174503e-06 0.0032200000000000002 2.6175659818148701e-06 0.0032300000000000002 -2.4972458283101252e-06 0.0032400000000000003 -1.1053394686848812e-06 0.0032500000000000003 1.037055599432001e-05 0.0032600000000000003 -1.5738599282538318e-06 0.0032700000000000003 -2.2675490970026254e-06 0.0032800000000000004 6.5629966788791691e-06 0.0032900000000000004 -4.8437655242484009e-06 0.0033000000000000004 1.9880044561705593e-06 0.0033100000000000004 6.9006162030264376e-08 0.0033200000000000005 -6.0779084400038658e-06 0.0033300000000000001 1.387236513667538e-06 0.0033400000000000001 -4.9955385758191924e-06 0.0033500000000000001 -6.369513041723981e-06 0.0033600000000000001 -8.4236483110054665e-06 0.0033700000000000002 -1.1476104633781134e-06 0.0033800000000000002 -9.8738756726682943e-08 0.0033900000000000002 -8.8941672719267496e-06 0.0034000000000000002 1.2399303945917392e-06 0.0034100000000000003 -2.2017972749166166e-06 0.0034200000000000003 9.6035914327767878e-06 0.0034300000000000003 1.9625649759535467e-06 0.0034400000000000003 -1.9410779025595343e-06 0.0034500000000000004 1.0553763501325306e-07 0.0034600000000000004 -1.2335447561071676e-05 0.0034700000000000004 -6.2325170055888918e-06 0.0034800000000000005 -3.9123387291004835e-06 0.0034900000000000005 7.3483006277360867e-07 0.0035000000000000001 1.0677041243675211e-05 0.0035100000000000001 2.6480444114291329e-08 0.0035200000000000001 -9.7083318909407175e-06 0.0035300000000000002 8.1472552876893383e-07 0.0035400000000000002 7.1111174001007173e-06 0.0035500000000000002 3.833530324185956e-06 0.0035600000000000002 1.2948865578971707e-06 0.0035700000000000003 -2.062530187481767e-06 0.0035800000000000003 3.4372752536550546e-06 0.0035900000000000003 -7.2234676304650779e-07 0.0036000000000000003 9.1746000727904853e-07 0.0036100000000000004 2.884151130048495e-06 0.0036200000000000004 -7.8509780080900724e-06 0.0036300000000000004 -4.2463319846797324e-06 0.0036400000000000004 -2.0641094247916744e-06 0.0036500000000000005 -4.3525944980144917e-06 0.0036600000000000005 -8.3191352430082149e-07 0.0036700000000000001 -2.5597859958154146e-06 0.0036800000000000001 -4.6626425728525061e-07 0.0036900000000000001 -3.715449746833587e-06 0.0037000000000000002 5.339982424925599e-06 0.0037100000000000002 1.1382437325663061e-05 0.0037200000000000002 -5.0039290867892411e-06 0.0037300000000000002 4.7674147687180498e-06 0.0037400000000000003 3.6477648177034187e-06 0.0037500000000000003 -2.8896367952789817e-06 0.0037600000000000003 -3.7167660008379179e-07 0.0037700000000000003 -7.5207700132511771e-06 0.0037800000000000004 -6.2431329638794114e-06 0.0037900000000000004 -1.1189632554576506e-05 0.0038000000000000004 1.0114603181901477e-05 0.0038100000000000005 1.8143632252750029e-06 0.0038200000000000005 -1.1961704299373855e-05 0.0038300000000000005 4.9765642633351146e-06 0.0038400000000000005 -5.8997057422311209e-06 0.0038500000000000001 -4.8227853363001173e-06 0.0038600000000000001 6.5316883839830101e-06 0.0038700000000000002 2.17491972937432e-06 0.0038800000000000002 2.0303902236543027e-06 0.0038900000000000002 -6.1000151585100055e-06 0.0039000000000000003 4.792599472407839e-06 0.0039100000000000003 -4.2904467848045256e-07 0.0039200000000000007 -3.3835316235591996e-06 0.0039300000000000003 6.7453157699483952e-06 0.0039399999999999999 -3.6111777133114106e-06 0.0039500000000000004 2.4935204780502815e-06 0.00396 9.1770513787937794e-10 0.0039700000000000004 3.6463859347241538e-06 0.00398 -1.0696934730716292e-06 0.0039900000000000005 -1.4901940569996788e-06 0.0040000000000000001 5.1709251022417463e-06 0.0040100000000000005 4.4461336410250671e-06 0.0040200000000000001 -1.869675159402858e-06 0.0040300000000000006 8.0727860876244844e-07 0.0040400000000000002 -5.3642068454772078e-06 0.0040500000000000006 -1.5927654799485592e-06 0.0040600000000000002 -7.6259880078114437e-07 0.0040700000000000007 3.6846926943493672e-06 0.0040800000000000003 -2.7986482258496224e-06 0.0040900000000000008 -5.5277478881296533e-06 0.0041000000000000003 6.271361437310964e-06 0.0041099999999999999 5.877710674282375e-07 0.0041200000000000004 -1.1223777995937632e-06 0.00413 6.5171933716757373e-06 0.0041400000000000005 -4.5938534826488287e-06 0.00415 -1.097742018647684e-05 0.0041600000000000005 -3.3329494301290199e-06 0.0041700000000000001 4.4714762915835226e-06 0.0041800000000000006 9.2992478230866779e-06 0.0041900000000000001 -1.6174832287897472e-06 0.0042000000000000006 -1.2008781690076728e-06 0.0042100000000000002 1.061523055445105e-05 0.0042200000000000007 -3.9935655801472408e-07 0.0042300000000000003 -1.5318833693596591e-06 0.0042400000000000007 -1.0834128119617043e-05 0.0042500000000000003 -7.0029487049705981e-06 0.0042600000000000008 -2.5946453527256473e-07 0.0042700000000000004 -7.035305649488211e-06 0.00428 -5.3384462812242741e-06 0.0042900000000000004 6.0384432674130446e-06 0.0043 1.717677551249897e-06 0.0043100000000000005 -7.7251323284926969e-07 0.0043200000000000001 -9.1893654773281529e-06 0.0043300000000000005 1.6579304279082559e-07 0.0043400000000000001 6.8814249754821764e-07 0.0043500000000000006 -1.0829842189508563e-06 0.0043600000000000002 -1.217466572435259e-06 0.0043700000000000006 -3.1609498646867105e-06 0.0043800000000000002 4.8984937979175476e-06 0.0043900000000000007 -8.5329327091339168e-06 0.0044000000000000003 -1.2684292681543015e-06 0.0044100000000000007 5.7938138271793454e-08 0.0044200000000000003 -2.8836172006530327e-06 0.0044300000000000008 1.7033104954733626e-06 0.0044400000000000004 1.7122662878533841e-07 0.00445 -7.5743513660841525e-06 0.0044600000000000004 -5.5021413692285931e-07 0.00447 -1.1908696218843034e-06 0.0044800000000000005 1.0078586493260301e-06 0.0044900000000000001 -4.8034558993218652e-07 0.0045000000000000005 -5.0255407148020619e-06 0.0045100000000000001 1.1847819633950297e-05 0.0045200000000000006 -3.6174424138129207e-06 0.0045300000000000002 -3.0516538421252423e-06 0.0045400000000000006 -1.6067039501111844e-06 0.0045500000000000002 3.3074754922527395e-06 0.0045600000000000007 -5.0789068599204417e-07 0.0045700000000000003 5.3143287728274774e-06 0.0045800000000000007 -1.6426180598091385e-06 0.0045900000000000003 1.0419781171657646e-06 0.0046000000000000008 5.3465597213583147e-07 0.0046100000000000004 2.755063714961304e-06 0.00462 -8.9277485480212506e-07 0.0046300000000000004 6.150504769219803e-06 0.00464 3.3756891093040979e-06 0.0046500000000000005 -1.4239852660285005e-06 0.0046600000000000001 9.7571817967120836e-06 0.0046700000000000005 1.7622831424534736e-06 0.0046800000000000001 6.3619048987816875e-06 0.0046900000000000006 -6.4692695833711465e-06 0.0047000000000000002 -1.0237640884760535e-06 0.0047100000000000006 -1.3320468380977254e-06 0.0047200000000000002 2.3824219552841524e-06 0.0047300000000000007 1.526919879730367e-06 0.0047400000000000003 -1.9632490218305327e-06 0.0047500000000000007 -2.5612451235688496e-06 0.0047600000000000003 -2.0319318611710607e-06 0.0047700000000000008 -1.4703961081134529e-06 0.0047800000000000004 -3.105646068468617e-06 0.00479 -2.196244970823954e-06 0.0048000000000000004 9.5623039394035755e-06 0.00481 -6.4438950486253992e-06 0.0048200000000000005 -2.6915552156481768e-06 0.0048300000000000001 -5.5953379831514112e-06 0.0048400000000000006 2.6383727652945441e-06 0.0048500000000000001 1.1362166098624432e-05 0.0048600000000000006 -5.0076103767837525e-06 0.0048700000000000002 -4.5153110734999024e-06 0.0048800000000000007 1.8600712490727019e-06 0.0048900000000000002 3.357558270616116e-06 0.0049000000000000007 1.5266268538634362e-06 0.0049100000000000003 -1.073290910012412e-06 0.0049200000000000008 1.6734111363431151e-06 0.0049300000000000004 -3.0108773752207025e-06 0.0049400000000000008 -2.131333715909432e-06 0.0049500000000000004 1.4601971167324014e-06 0.00496 -2.2071638080141728e-06 0.0049700000000000005 1.2250803357647081e-05 0.0049800000000000001 -1.6709428169496786e-06 0.0049900000000000005 -2.8216523785697858e-06 0.0050000000000000001 -2.9259509986250064e-07 0.0050100000000000006 -4.7248668398273462e-06 0.0050200000000000002 2.2907159602864422e-06 0.0050300000000000006 2.2682346257368855e-06 0.0050400000000000002 -3.4130669658619631e-06 0.0050500000000000007 2.2960007155606747e-06 0.0050600000000000003 1.0138877554370547e-09 0.0050700000000000007 -5.339543825130241e-06 0.0050800000000000003 -7.1375677162062308e-06 0.0050900000000000008 3.1650760551725805e-06 0.0051000000000000004 -1.2400687960745316e-06 0.0051100000000000008 2.0593175489432754e-06 0.0051200000000000004 5.0785126961677964e-06 0.00513 1.0683807192958909e-06 0.0051400000000000005 -5.1499879374354798e-07 0.0051500000000000001 -8.7050688525691714e-06 0.0051600000000000005 -5.589093360619924e-06 0.0051700000000000001 -1.0445808443016095e-05 0.0051800000000000006 6.1315758077732224e-06 0.0051900000000000002 5.0612143018792838e-06 0.0052000000000000006 4.5158117477471571e-06 0.0052100000000000002 3.3499342811964431e-07 0.0052200000000000007 5.5166848887901448e-06 0.0052300000000000003 5.6988058480095499e-06 0.0052400000000000007 -7.2121202292708138e-06 0.0052500000000000003 -6.6523852456466544e-06 0.0052600000000000008 2.9480320877935136e-06 0.0052700000000000004 3.2875091435763023e-06 0.0052800000000000008 3.6715950149992245e-06 0.0052900000000000004 1.7141974223655322e-06 0.0053 5.6989745362791837e-06 0.0053100000000000005 -1.2193125801257286e-05 0.0053200000000000001 5.0863891910727605e-06 0.0053300000000000005 -4.0192523753631352e-06 0.0053400000000000001 7.4097198127840161e-06 0.0053500000000000006 -2.5783453891415495e-06 0.0053600000000000002 1.1263706717508495e-06 0.0053700000000000006 -4.0510712543923187e-06 0.0053800000000000002 8.2302075583341021e-06 0.0053900000000000007 -7.0263897284010822e-06 0.0054000000000000003 1.3961860187036061e-06 0.0054100000000000007 -1.5341071118325456e-06 0.0054200000000000003 -1.9453165801603063e-06 0.0054300000000000008 -4.8075016221685768e-06 0.0054400000000000004 -5.8035765992513449e-07 0.0054500000000000009 5.8852419770444338e-06 0.0054600000000000004 -1.4459600716020487e-06 0.00547 -2.8194723742906803e-06 0.0054800000000000005 -5.7456667699025983e-06 0.0054900000000000001 5.7891666432914587e-06 0.0055000000000000005 2.790370545310644e-06 0.0055100000000000001 1.382332846422273e-07 0.0055200000000000006 6.0932834907639312e-06 0.0055300000000000002 7.1493465522187553e-06 0.0055400000000000007 7.5395183152890551e-06 0.0055500000000000002 8.5412570063810716e-06 0.0055600000000000007 -1.0255274773262316e-06 0.0055700000000000003 -6.1074467481935563e-06 0.0055800000000000008 -4.890712479728708e-06 0.0055900000000000004 4.3442469790805282e-07 0.0056000000000000008 8.429212033082161e-06 0.0056100000000000004 7.3113574060677083e-06 0.0056200000000000009 2.6505463904415712e-06 0.0056300000000000005 -3.688550738945561e-06 0.00564 1.129889893284799e-06 0.0056500000000000005 -4.9796805818532465e-06 0.0056600000000000001 4.617929351907698e-06 0.0056700000000000006 4.7100248223475215e-08 0.0056800000000000002 -9.1134742186922033e-06 0.0056900000000000006 -3.7698624824617418e-07 0.0057000000000000002 -6.2880423704656715e-06 0.0057100000000000007 5.3844634700987705e-06 0.0057200000000000003 -1.066807001101999e-05 0.0057300000000000007 1.6915714907843625e-07 0.0057400000000000003 3.5543508501002832e-06 0.0057500000000000008 -4.3422561219377098e-06 0.0057600000000000004 6.1173989979424128e-06 0.0057700000000000008 -1.8939565942705871e-06 0.0057800000000000004 -4.4703295864155296e-06 0.0057900000000000009 4.0200398212535102e-06 0.0058000000000000005 -4.7629870701178755e-06 0.0058100000000000001 8.4686583358372786e-06 0.0058200000000000005 -9.4215356943000542e-06 0.0058300000000000001 -6.1386267767285056e-06 0.0058400000000000006 1.1092471130065112e-05 0.0058500000000000002 5.1687460914502689e-06 0.0058600000000000006 5.7771883331179395e-06 0.0058700000000000002 -1.852190378312871e-06 0.0058800000000000007 1.1060244632644597e-05 0.0058900000000000003 -3.5756243014683208e-06 0.0059000000000000007 -1.4881402910778681e-06 0.0059100000000000003 8.4218970339220842e-07 0.0059200000000000008 3.8596889509858917e-06 0.0059300000000000004 -1.6561378733658116e-05 0.0059400000000000008 -9.4317866880257388e-06 0.0059500000000000004 -3.3175724885366688e-07 0.0059600000000000009 -6.4421155408596848e-06 0.0059700000000000005 -1.8969240677924444e-06 0.0059800000000000001 3.3944793213154619e-06 0.0059900000000000005 9.4992140838809735e-06 0.0060000000000000001 -1.0485949001548952e-05 0.0060100000000000006 -8.6557040108708751e-06 0.0060200000000000002 -1.0077379066242834e-05 0.0060300000000000006 1.7364329277253538e-06 0.0060400000000000002 -6.2574406875673582e-07 0.0060500000000000007 -2.9164470624245604e-06 0.0060600000000000003 -3.0466020547134929e-06 0.0060700000000000007 5.9755116993775988e-06 0.0060800000000000003 -2.0496609526366353e-06 0.0060900000000000008 -3.8533437624165591e-06 0.0061000000000000004 3.8285721917057301e-07 0.0061100000000000008 -1.5817133361558434e-06 0.0061200000000000004 -2.9265538222771772e-06 0.0061300000000000009 -6.2679684088460154e-06 0.0061400000000000005 -9.8810398677695767e-06 0.0061500000000000001 -4.4583590803358227e-08 0.0061600000000000005 4.5436391473789463e-06 0.0061700000000000001 2.1262903339558612e-07 0.0061800000000000006 1.2215632173668453e-06 0.0061900000000000002 -1.4787970524426984e-06 0.0062000000000000006 5.9895247308617266e-07 0.0062100000000000002 5.0043862683472719e-07 0.0062200000000000007 -3.4238775516295114e-06 0.0062300000000000003 -3.986353645876004e-06 0.0062400000000000008 -7.0009339672352586e-06 0.0062500000000000003 -5.7262806014174991e-06 0.0062600000000000008 -3.6276344683353114e-06 0.0062700000000000004 2.422985733906804e-06 0.0062800000000000009 -8.4937278174916671e-06 0.0062900000000000005 1.0371339074845954e-06 0.0063000000000000009 -2.792400615020878e-06 0.0063100000000000005 -6.7465577296291915e-06 0.0063200000000000001 8.2266030143857704e-06 0.0063300000000000006 -3.3369723764517135e-07 0.0063400000000000001 -1.2513532309454751e-07 0.0063500000000000006 -5.5988881323209836e-06 0.0063600000000000002 4.4367761189538103e-07 0.0063700000000000007 -5.2641797770083756e-06 0.0063800000000000003 -1.2241633903356883e-05 0.0063900000000000007 2.881562090486767e-06 0.0064000000000000003 -1.6204861838979288e-06 0.0064100000000000008 -4.3944408111675411e-06 0.0064200000000000004 3.0210120518700457e-06 0.0064300000000000008 2.3458452773105518e-06 0.0064400000000000004 -2.5907761670570531e-06 0.0064500000000000009 -5.3398579314978731e-07 0.0064600000000000005 -6.4091178546136069e-07 0.0064700000000000009 4.479318501057897e-06 0.0064800000000000005 -4.3963485041992767e-06 0.0064900000000000001 9.7173516743734168e-07 0.0065000000000000006 -1.6254909222414392e-06 0.0065100000000000002 4.8886581413439657e-06 0.0065200000000000006 1.8810574622269997e-06 0.0065300000000000002 3.3457134568253033e-07 0.0065400000000000007 -3.8892544333072421e-06 0.0065500000000000003 2.9497115368146622e-07 0.0065600000000000007 -2.584558563291649e-06 0.0065700000000000003 5.8470026300866664e-06 0.0065800000000000008 3.4342495619224801e-06 0.0065900000000000004 1.8208654650426295e-06 0.0066000000000000008 -6.6595912254285956e-08 0.0066100000000000004 1.1985749735698176e-05 0.0066200000000000009 -7.2238533757049238e-07 0.0066300000000000005 4.5665380247477091e-06 0.0066400000000000009 6.1188223166513669e-07 0.0066500000000000005 2.3627302273234272e-06 0.0066600000000000001 4.3428249149454697e-06 0.0066700000000000006 2.6067157136836103e-06 0.0066800000000000002 1.0454709701496295e-05 0.0066900000000000006 -6.4500052228992506e-06 0.0067000000000000002 1.6717020966998618e-06 0.0067100000000000007 3.5734732605419522e-06 0.0067200000000000003 -6.785086451647088e-06 0.0067300000000000007 -4.5630922231989094e-06 0.0067400000000000003 -6.9564934285757669e-06 0.0067500000000000008 8.465220426244131e-06 0.0067600000000000004 -2.8311254740180123e-06 0.0067700000000000008 -3.2318374754487989e-06 0.0067800000000000004 -1.8186179214990582e-06 0.0067900000000000009 -1.4167252711497542e-06 0.0068000000000000005 -7.3144084823390629e-06 0.0068100000000000009 5.0459232398177251e-06 0.0068200000000000005 7.1794250327719532e-06 0.0068300000000000001 7.3364016889971644e-06 0.0068400000000000006 -4.0439541943103768e-06 0.0068500000000000002 -5.3380271654649759e-07 0.0068600000000000006 -4.26485941855901e-06 0.0068700000000000002 -6.563767632062639e-06 0.0068800000000000007 4.8443265655855548e-06 0.0068900000000000003 -1.6608151777488319e-06 0.0069000000000000008 5.4230441171580625e-06 0.0069100000000000003 -4.7596746223821719e-06 0.0069200000000000008 -9.007083626484743e-07 0.0069300000000000004 -8.986261500455638e-06 0.0069400000000000009 4.6144118297806864e-06 0.0069500000000000004 4.4712983576077179e-06 0.0069600000000000009 -5.0863457511023152e-06 0.0069700000000000005 6.9387411163863824e-08 0.006980000000000001 5.7318518868667657e-06 0.0069900000000000006 -4.850836573764613e-06 0.0070000000000000001 -2.097936362538883e-06 0.0070100000000000006 2.3002801897035602e-06 0.0070200000000000002 4.4316757729560472e-07 0.0070300000000000007 3.3031519264035492e-06 0.0070400000000000003 9.9697707472835491e-06 0.0070500000000000007 5.2464226551727185e-06 0.0070600000000000003 -1.6886237707949432e-06 0.0070700000000000008 -6.738591987514451e-07 0.0070800000000000004 1.3714371086928813e-06 0.0070900000000000008 -4.256551562954166e-06 0.0071000000000000004 -1.0221207396143097e-06 0.0071100000000000009 2.8580198510819483e-07 0.0071200000000000005 2.8885662331967213e-06 0.0071300000000000009 -1.6586286963773477e-06 0.0071400000000000005 -7.8494810364215399e-07 0.007150000000000001 -1.7748779356388749e-06 0.0071600000000000006 -5.8995103747670567e-06 0.0071700000000000002 1.946191899501732e-06 0.0071800000000000006 -1.7761453198761004e-06 0.0071900000000000002 -6.5498897465452203e-06 0.0072000000000000007 -4.3129912819727734e-06 0.0072100000000000003 -7.6143440256464471e-06 0.0072200000000000007 4.5966159821497655e-06 0.0072300000000000003 5.0725073608299357e-07 0.0072400000000000008 3.6004246007110678e-06 0.0072500000000000004 5.1690376520216025e-06 0.0072600000000000008 -9.4335924549274068e-07 0.0072700000000000004 1.0464844744067514e-06 0.0072800000000000009 -1.4581153945478001e-06 0.0072900000000000005 7.5431399149196749e-06 0.0073000000000000009 -2.5041951898474598e-06 0.0073100000000000005 -1.4773696266267363e-05 0.007320000000000001 8.4919357494712128e-06 0.0073300000000000006 3.0248572895042993e-06 0.0073400000000000002 1.9138848768096095e-06 0.0073500000000000006 1.410541698797786e-06 0.0073600000000000002 7.9293080563754254e-06 0.0073700000000000007 -7.709226367207909e-07 0.0073800000000000003 1.9524790590419903e-06 0.0073900000000000007 -1.5115551465938642e-07 0.0074000000000000003 -1.2722320656568961e-05 0.0074100000000000008 8.5015948493206717e-06 0.0074200000000000004 5.7410598689555308e-06 0.0074300000000000008 -9.847047098781749e-06 0.0074400000000000004 -5.3842922381687038e-06 0.0074500000000000009 -3.0885942102055579e-06 0.0074600000000000005 -3.0747539494336443e-06 0.0074700000000000009 -3.5559282159537249e-06 0.0074800000000000005 1.9214302266749227e-07 0.007490000000000001 1.7358572894682226e-06 0.0075000000000000006 -9.8747540986111775e-06 0.0075100000000000002 9.1332787494982103e-07 0.0075200000000000006 2.9905371555534473e-06 0.0075300000000000002 -8.3068232243378088e-06 0.0075400000000000007 9.4155303151085556e-06 0.0075500000000000003 4.1202630337490281e-06 0.0075600000000000007 1.7376707538968637e-06 0.0075700000000000003 -3.2691965254886905e-06 0.0075800000000000008 -4.9453392023604782e-06 0.0075900000000000004 -5.4679866878178693e-06 0.0076000000000000009 -2.8491079183780872e-06 0.0076100000000000004 5.0110755734128282e-06 0.0076200000000000009 -2.609188436009014e-06 0.0076300000000000005 1.1612504764144026e-05 0.007640000000000001 -6.4842048652014734e-06 0.0076500000000000005 1.1021949927645511e-06 0.007660000000000001 8.9784750411147277e-07 0.0076700000000000006 -3.8605613056965928e-06 0.0076800000000000011 -4.0658279566808522e-06 0.0076900000000000007 2.4349792671967199e-06 0.0077000000000000002 -4.7107215289589233e-06 0.0077100000000000007 6.3984485798812867e-06 0.0077200000000000003 -4.5309406576237776e-06 0.0077300000000000008 7.2103754574371578e-06 0.0077400000000000004 -3.8536432972829324e-06 0.0077500000000000008 8.1364908247382761e-06 0.0077600000000000004 -4.7370599423326405e-06 0.0077700000000000009 1.5382122479055284e-06 0.0077800000000000005 -3.8124903832185594e-06 0.0077900000000000009 2.6318286903425537e-06 0.0078000000000000005 9.8558743005029668e-07 0.007810000000000001 5.0210076166045727e-06 0.0078200000000000006 2.6241740581008879e-06 0.0078300000000000002 -6.0372736802694429e-06 0.0078400000000000015 -2.3679165099219808e-06 0.0078500000000000011 -3.6054962247783186e-06 0.0078600000000000007 1.2155048052720695e-06 0.0078700000000000003 5.2213355906054499e-06 0.0078799999999999999 5.5135398474255994e-06 0.0078900000000000012 3.271185992653312e-06 0.0079000000000000008 -1.2014027601882365e-06 0.0079100000000000004 -6.1949742344528853e-07 0.00792 -4.0931121997084589e-06 0.0079300000000000013 1.4980215452830892e-06 0.0079400000000000009 2.0878548188479729e-06 0.0079500000000000005 2.7870949724342907e-06 0.0079600000000000001 -9.4663079726342003e-07 0.0079700000000000014 6.0676488909328004e-06 0.007980000000000001 -2.0344920904040818e-06 0.0079900000000000006 8.6961902714694994e-07 0.0080000000000000002 2.0457162751394153e-06 0.0080100000000000015 3.0812642117334229e-06 0.0080200000000000011 4.4030218695956908e-06 0.0080300000000000007 4.5383250066155495e-06 0.0080400000000000003 5.8093730491207799e-06 0.0080499999999999999 -2.6313348451270539e-06 0.0080600000000000012 2.5469496889069838e-06 0.0080700000000000008 8.6605666636504176e-06 0.0080800000000000004 4.152972334000424e-06 0.00809 6.4883930780066586e-06 0.0081000000000000013 -9.5734409025975598e-06 0.0081100000000000009 9.470822580813566e-06 0.0081200000000000005 1.7900085419313019e-06 0.0081300000000000001 -7.7472156376652008e-07 0.0081400000000000014 2.5388800327749381e-06 0.008150000000000001 2.7402324086568633e-06 0.0081600000000000006 2.0707260412817751e-06 0.0081700000000000002 -4.0158525771523011e-07 0.0081800000000000015 1.2214172814893693e-07 0.0081900000000000011 1.3588122007139768e-05 0.0082000000000000007 -1.729890574078426e-06 0.0082100000000000003 -1.8123128987214315e-06 0.0082199999999999999 6.8552453697489022e-06 0.0082300000000000012 6.0240341899902007e-06 0.0082400000000000008 1.7884385627755e-06 0.0082500000000000004 -5.5186004590616691e-06 0.00826 -5.9835656749993587e-06 0.0082700000000000013 3.4008577948072045e-06 0.0082800000000000009 -8.9992080996293116e-06 0.0082900000000000005 -3.8011449170195839e-06 0.0083000000000000001 9.635251931130068e-06 0.0083100000000000014 -1.5246681077802801e-05 0.008320000000000001 -2.2272636587123726e-08 0.0083300000000000006 -4.834591244881283e-06 0.0083400000000000002 1.6849174425714471e-06 0.0083500000000000015 8.2341784981805328e-07 0.0083600000000000011 -6.2455659184273055e-06 0.0083700000000000007 4.9753430832227893e-06 0.0083800000000000003 -3.0765212168607943e-06 0.0083899999999999999 -3.3708291814677408e-06 0.0084000000000000012 3.2806774299078033e-06 0.0084100000000000008 7.2260586374007422e-06 0.0084200000000000004 3.3410046023005627e-06 0.00843 9.8474941015585681e-06 0.0084400000000000013 1.0861464876342913e-06 0.0084500000000000009 2.7697387318893697e-06 0.0084600000000000005 -1.3403356817388628e-05 0.0084700000000000001 3.1611164056740441e-06 0.0084800000000000014 3.8984101401798113e-06 0.008490000000000001 -3.2354653948828008e-06 0.0085000000000000006 1.291692063364579e-06 0.0085100000000000002 -7.5075322413576765e-07 0.0085200000000000015 -2.6433789031056239e-06 0.0085300000000000011 -2.5304475726757567e-06 0.0085400000000000007 -2.1960076636586204e-06 0.0085500000000000003 -7.8627126701296506e-07 0.0085599999999999999 3.4394168995641473e-06 0.0085700000000000012 7.1753399638307428e-06 0.0085800000000000008 8.8547525632836668e-07 0.0085900000000000004 -4.7187890495907588e-07 0.0086 -7.4542843028079059e-06 0.0086100000000000013 5.5521495242107996e-06 0.0086200000000000009 9.3992419694845518e-06 0.0086300000000000005 -3.8348287277515467e-06 0.0086400000000000001 4.5056643549186423e-07 0.0086500000000000014 -6.9281829080769501e-08 0.008660000000000001 -4.4272929884328571e-06 0.0086700000000000006 -3.801637913943006e-06 0.0086800000000000002 3.1066889968492756e-06 0.0086900000000000015 -1.1181556206717245e-06 0.0087000000000000011 1.6579920378087024e-06 0.0087100000000000007 4.8966194595113489e-06 0.0087200000000000003 -3.4461458652440744e-07 0.0087299999999999999 -3.8799832512703209e-06 0.0087400000000000012 -3.0946566451548249e-06 0.0087500000000000008 5.8351998368782193e-06 0.0087600000000000004 1.5411705369689354e-06 0.00877 6.7723980797773815e-06 0.0087800000000000013 -5.3293666797508383e-07 0.0087900000000000009 -6.0275994858600021e-06 0.0088000000000000005 1.9895904126784416e-06 0.0088100000000000001 -1.1447169504681559e-05 0.0088200000000000014 -7.1169843611678821e-06 0.008830000000000001 3.0103228108825449e-07 0.0088400000000000006 1.0392251732614084e-06 0.0088500000000000002 -2.7452153164330219e-06 0.0088600000000000016 -1.3359616918699219e-07 0.0088700000000000011 -8.2571104937502431e-07 0.0088800000000000007 6.0228079590746379e-06 0.0088900000000000003 -1.6140013657121539e-06 0.0088999999999999999 2.9279348782922061e-06 0.0089100000000000013 3.0169002201614943e-06 0.0089200000000000008 6.0801944078167833e-06 0.0089300000000000004 2.8742986624897157e-06 0.00894 -7.7398162731496335e-07 0.0089500000000000014 6.4679784721475688e-06 0.0089600000000000009 3.1460289183708304e-07 0.0089700000000000005 -9.2587481324092138e-07 0.0089800000000000001 4.9043514484527705e-06 0.0089900000000000015 -7.0512294454052599e-06 0.0090000000000000011 -1.4055973346774288e-06 0.0090100000000000006 -2.5341380254200117e-06 0.0090200000000000002 -5.9023852370692402e-07 0.0090300000000000016 -1.9586015768351733e-07 0.0090400000000000012 -3.2812289213636323e-06 0.0090500000000000008 2.6045772986671647e-06 0.0090600000000000003 4.5362658085469137e-06 0.0090699999999999999 -2.1728568808124717e-06 0.0090800000000000013 4.5369313203217944e-06 0.0090900000000000009 -6.0700873487264732e-07 0.0091000000000000004 -3.6766531990594846e-06 0.00911 -1.1893287050050439e-05 0.0091200000000000014 7.8887641205786025e-07 0.009130000000000001 -2.3511110385640994e-07 0.0091400000000000006 -6.0557813380072315e-06 0.0091500000000000001 7.292993119339653e-06 0.0091600000000000015 3.9239226063821193e-06 0.0091700000000000011 2.3864619014161656e-06 0.0091800000000000007 -3.6935900492584042e-06 0.0091900000000000003 7.0155613706222529e-06 0.0092000000000000016 5.9315785062539462e-06 0.0092100000000000012 -1.3270826993038257e-07 0.0092200000000000008 -1.1778984409273691e-07 0.0092300000000000004 -1.3700553068521368e-06 0.0092399999999999999 -2.6661728361776627e-06 0.0092500000000000013 1.7704315424894026e-06 0.0092600000000000009 5.2964576769370381e-06 0.0092700000000000005 -1.9691615361718655e-06 0.0092800000000000001 1.6108579567766926e-06 0.0092900000000000014 -5.4013998448892689e-06 0.009300000000000001 6.2780153929604513e-06 0.0093100000000000006 5.1772948531302561e-06 0.0093200000000000002 -1.7064532286789717e-06 0.0093300000000000015 4.2953422423516253e-06 0.0093400000000000011 -8.2348201960555206e-08 0.0093500000000000007 -2.9372717563279544e-08 0.0093600000000000003 1.634452225149412e-06 0.0093700000000000016 -3.9748681717736535e-07 0.0093800000000000012 2.6015869812064485e-06 0.0093900000000000008 -1.4628077269798696e-06 0.0094000000000000004 -9.6647898396137104e-06 0.00941 5.4055395819139008e-06 0.0094200000000000013 -4.8927046264495579e-07 0.0094300000000000009 -2.7016746840111859e-06 0.0094400000000000005 -7.2944330460186608e-06 0.0094500000000000001 -4.5397960539076857e-06 0.0094600000000000014 1.946772759940501e-06 0.009470000000000001 -4.3470066700448139e-06 0.0094800000000000006 6.4137499160872363e-06 0.0094900000000000002 4.3907534391005146e-06 0.0095000000000000015 -9.3702658670497639e-06 0.0095100000000000011 -1.3639367721054598e-06 0.0095200000000000007 -1.0928707582616967e-06 0.0095300000000000003 2.276564111119714e-06 0.0095400000000000016 5.393239788120926e-06 0.0095500000000000012 -6.5317066556286761e-06 0.0095600000000000008 8.8184908168940205e-06 0.0095700000000000004 -8.9741431127914768e-06 0.00958 3.8973259010891729e-06 0.0095900000000000013 5.6925838431755343e-06 0.0096000000000000009 -5.7583650514118826e-06 0.0096100000000000005 6.8742734939450006e-07 0.0096200000000000001 -5.9274838403724567e-06 0.0096300000000000014 -4.9540559887167421e-06 0.009640000000000001 -9.5231552786499084e-06 0.0096500000000000006 7.6551033512093202e-06 0.0096600000000000002 8.30102694744613e-06 0.0096700000000000015 2.9982785033239716e-07 0.0096800000000000011 -1.539599580734986e-07 0.0096900000000000007 -1.7245088870895364e-06 0.0097000000000000003 -5.4354745549647761e-06 0.0097100000000000016 -4.7696468582185897e-07 0.0097200000000000012 8.9775624763496343e-07 0.0097300000000000008 4.2799777803354377e-06 0.0097400000000000004 7.4967121050921994e-06 0.00975 -1.7623714761819117e-06 0.0097600000000000013 -1.8984897381303649e-06 0.0097700000000000009 1.6423049503423105e-06 0.0097800000000000005 -8.6447267717719302e-06 0.0097900000000000001 2.8819586635953708e-06 0.0098000000000000014 2.2241289503672102e-06 0.009810000000000001 -3.2578950435822527e-06 0.0098200000000000006 -1.4828932507977262e-06 0.0098300000000000002 1.1241081018635063e-05 0.0098400000000000015 -7.0178139135173575e-06 0.0098500000000000011 -3.4443700565297948e-06 0.0098600000000000007 -1.3389360759851145e-06 0.0098700000000000003 4.205508256354098e-06 0.0098800000000000016 -3.9802530400054758e-06 0.0098900000000000012 2.3478624703064997e-06 0.0099000000000000008 4.4658918315714762e-07 0.0099100000000000004 5.9464173754979236e-06 0.00992 -4.4841612850400209e-06 0.0099300000000000013 1.7642299193640084e-06 0.0099400000000000009 -7.0652122025144096e-06 0.0099500000000000005 -7.5320999839214311e-07 0.0099600000000000001 6.5883847785397774e-07 0.0099700000000000014 4.4069397972175794e-06 0.009980000000000001 -5.7508436155141104e-06 0.0099900000000000006 1.2092277517975677e-05 0.01 -5.8540977390917607e-06 0.010010000000000002 3.7749588329600358e-07 0.010020000000000001 1.1140826868194679e-05 0.010030000000000001 6.4054428690138635e-06 0.01004 1.6639038513287212e-06 0.010050000000000002 6.1889399385193125e-06 0.010060000000000001 4.5382623086118546e-06 0.010070000000000001 -3.6266161224051642e-06 0.01008 -3.0044072058424469e-06 0.01009 -6.9599966113874997e-06 0.010100000000000001 5.1514947107946188e-06 0.010110000000000001 -3.2478042205043604e-06 0.010120000000000001 -1.6687722363513009e-06 0.01013 -3.507476432255742e-06 0.010140000000000001 3.6116632613176709e-06 0.010150000000000001 7.5665097753906947e-06 0.010160000000000001 -5.9291867119311523e-06 0.01017 -3.2078417220785847e-06 0.010180000000000002 2.2622598373702485e-06 0.010190000000000001 4.6038068252435901e-06 0.010200000000000001 2.6553132461171317e-06 0.01021 1.2626936022267506e-06 0.010220000000000002 -4.2001608175672712e-06 0.010230000000000001 -5.5980379801779851e-06 0.010240000000000001 3.8181174592753033e-06 0.01025 5.4931436365544689e-06 0.01026 -4.7117952231188926e-06 0.010270000000000001 -1.0481180245954639e-07 0.010280000000000001 -1.4039847882286486e-06 0.010290000000000001 -5.8681029905665675e-06 0.0103 -4.1576697839231247e-06 0.010310000000000001 2.2886553210300712e-06 0.010320000000000001 6.2756236337080232e-06 0.010330000000000001 2.5035472062277614e-06 0.01034 -2.9556926949969022e-06 0.010350000000000002 4.032199560755972e-06 0.010360000000000001 -5.2099114521482252e-06 0.010370000000000001 -2.7609704908469569e-06 0.01038 1.8973038444498634e-06 0.010390000000000002 7.2732608582810883e-07 0.010400000000000001 -3.3070933830439478e-06 0.010410000000000001 3.1242256211269001e-06 0.01042 -3.361104395105242e-06 0.01043 -6.5359765590982609e-06 0.010440000000000001 -7.6276752584341142e-06 0.010450000000000001 2.8132954471736158e-06 0.010460000000000001 -7.9181268792261106e-06 0.01047 -4.7683047639223598e-06 0.010480000000000001 8.6943352834012773e-07 0.010490000000000001 3.2651109150530165e-07 0.010500000000000001 -1.2640721759424311e-05 0.01051 1.3793861394929258e-06 0.010520000000000002 9.0542644105178318e-07 0.010530000000000001 -9.7984402943735431e-07 0.010540000000000001 1.1833426086231233e-06 0.01055 -3.2919153132930181e-06 0.010560000000000002 3.7610049659269189e-06 0.010570000000000001 2.6064564417784231e-06 0.010580000000000001 -6.0222261747099152e-06 0.01059 2.6285046277962422e-06 0.0106 -3.3352334561268068e-06 0.010610000000000001 -1.0628076773325212e-06 0.010620000000000001 -2.5369310968663923e-06 0.010630000000000001 -2.8269275714249121e-06 0.01064 1.5563445611376407e-06 0.010650000000000001 -6.2667283129202419e-06 0.010660000000000001 1.5479479730562433e-06 0.010670000000000001 3.7589153458729172e-06 0.01068 -4.0179032745727924e-06 0.010690000000000002 -1.5984358905961075e-06 0.010700000000000001 1.0418549741121936e-05 0.010710000000000001 -1.0999592930552514e-05 0.01072 6.3637588345259028e-06 0.010730000000000002 -4.6595224608879707e-06 0.010740000000000001 -5.4041447626869802e-06 0.010750000000000001 -7.4392783216676209e-06 0.01076 -4.7048264236460279e-06 0.01077 1.3613443066367391e-05 0.010780000000000001 -3.9801094992695615e-06 0.010790000000000001 5.9736310779640724e-06 0.010800000000000001 -5.3423296622234768e-06 0.01081 -6.1158689446453326e-06 0.010820000000000001 2.3339100830364508e-06 0.010830000000000001 6.4381903392188642e-06 0.010840000000000001 -4.9347599091289166e-06 0.01085 -2.6673091876113581e-06 0.010860000000000002 2.70557881744351e-06 0.010870000000000001 -1.3836521785026251e-06 0.010880000000000001 9.3894628127372099e-06 0.01089 7.3341187406005985e-07 0.010900000000000002 -7.2708237497514923e-06 0.010910000000000001 -1.089339051853509e-05 0.010920000000000001 -4.5701358437792324e-06 0.01093 6.131809435610229e-08 0.01094 1.0628127478651406e-05 0.010950000000000001 -8.8971815962216195e-07 0.010960000000000001 4.7726287203910673e-06 0.010970000000000001 3.1879547010009009e-06 0.01098 -1.578950153998944e-06 0.010990000000000002 -2.7223412475531104e-06 0.011000000000000001 -3.1689588187827774e-07 0.011010000000000001 -4.4563831053018091e-06 0.01102 -5.4920555607985734e-06 0.011030000000000002 -6.7624434609212232e-06 0.011040000000000001 2.910259504785521e-06 0.011050000000000001 7.1155088328985052e-06 0.01106 3.8309469845296457e-06 0.011070000000000002 -4.1482296584603617e-06 0.011080000000000001 1.7741469117373321e-06 0.011090000000000001 -4.1499999876449014e-06 0.0111 -3.8604956668409816e-06 0.01111 3.518892031821416e-06 0.011120000000000001 5.6726384464926077e-06 0.011130000000000001 9.3090509808165703e-06 0.011140000000000001 1.0405018399555282e-06 0.01115 -1.6576251657080727e-06 0.011160000000000002 -5.2895796188272061e-06 0.011170000000000001 1.6546631354748543e-06 0.011180000000000001 -4.9689911628438033e-06 0.01119 1.194981997899401e-07 0.011200000000000002 -6.9027091245476844e-06 0.011210000000000001 -2.1209013071320419e-06 0.011220000000000001 -4.4468518225245274e-06 0.01123 -2.6240227666340778e-06 0.011240000000000002 4.3798343231347342e-06 0.011250000000000001 1.9128719711217119e-06 0.011260000000000001 -2.1860310021138373e-06 0.011270000000000001 -3.1640019742975007e-06 0.01128 2.1621241361096602e-06 0.011290000000000001 3.2681709237453733e-06 0.011300000000000001 2.9830937330898502e-06 0.011310000000000001 3.7847192854551145e-06 0.01132 -8.8399883652520661e-06 0.011330000000000002 -2.6638880274170264e-06 0.011340000000000001 -1.3880179012523827e-05 0.011350000000000001 7.1553661008988506e-06 0.01136 -3.8815184504341533e-06 0.011370000000000002 -7.2010433352527906e-06 0.011380000000000001 4.1584188740873735e-06 0.011390000000000001 4.8205998300993753e-06 0.0114 -4.5469056199823115e-06 0.011410000000000002 4.4848531946136816e-06 0.011420000000000001 -2.1961826853579519e-06 0.011430000000000001 1.1447281621449326e-05 0.011440000000000001 6.8723797773518402e-07 0.01145 -4.1154848744991814e-07 0.011460000000000001 8.409255813598437e-06 0.011470000000000001 3.5658648234685541e-06 0.011480000000000001 -8.481924147798108e-06 0.01149 -3.3987590733382923e-06 0.011500000000000002 5.9907189446609595e-06 0.011510000000000001 -4.1500861790981858e-06 0.011520000000000001 -8.836728458455066e-06 0.01153 8.7808605926936999e-06 0.011540000000000002 -5.1897570269432813e-07 0.011550000000000001 -8.3356482595648017e-06 0.011560000000000001 -1.6918820332767826e-06 0.01157 -4.813223756212342e-06 0.011580000000000002 -1.1504928695748333e-06 0.011590000000000001 4.8497844874670615e-06 0.011600000000000001 -5.7689477297270276e-06 0.011610000000000001 8.6378571408909845e-06 0.01162 2.8790735842029588e-06 0.011630000000000001 5.901919782480328e-06 0.011640000000000001 -4.1728354135274832e-07 0.011650000000000001 8.1456464610607139e-06 0.01166 -5.3896846610801475e-06 0.011670000000000002 1.3180628221230907e-05 0.011680000000000001 -2.0609552026333204e-06 0.011690000000000001 -6.8269500492856964e-07 0.0117 -3.835118406990821e-06 0.011710000000000002 4.7821410345223643e-06 0.011720000000000001 9.7151688400351089e-06 0.011730000000000001 -8.1376722454384421e-06 0.01174 8.8820262039567484e-06 0.011750000000000002 -3.055399160721232e-06 0.011760000000000001 6.1866375046276716e-06 0.011770000000000001 -2.4077058293053115e-06 0.011780000000000001 -5.4803299441374506e-06 0.01179 7.6374113145034816e-06 0.011800000000000001 2.7401511848164038e-06 0.011810000000000001 3.2907508816326721e-06 0.011820000000000001 -1.9220090259575877e-06 0.01183 2.4434473353447564e-06 0.011840000000000002 5.6413361068851232e-06 0.011850000000000001 3.2774011504095238e-06 0.011860000000000001 -3.2734505132177811e-06 0.01187 -3.7655150215129195e-06 0.011880000000000002 -7.9678924230688525e-06 0.011890000000000001 -5.7074896085869917e-06 0.011900000000000001 1.8898354423822735e-06 0.01191 4.5994709396517549e-06 0.011920000000000002 3.002223455916296e-06 0.011930000000000001 7.5202739484931085e-06 0.011940000000000001 1.1953294019621268e-06 0.011950000000000001 -5.2402636708800073e-06 0.01196 -2.6071729777970474e-07 0.011970000000000001 -4.5994190814513599e-07 0.011980000000000001 -3.5521713785956614e-07 0.011990000000000001 -4.3726911408849429e-06 0.012 9.8347080783118143e-07 0.012010000000000002 3.5354187271390357e-06 0.012020000000000001 -3.4843293532772503e-06 0.012030000000000001 -2.1349520868573235e-06 0.01204 -5.9561140651514251e-07 0.012050000000000002 -4.5568265650455211e-06 0.012060000000000001 -1.3418393691660574e-06 0.012070000000000001 -9.2152027929685757e-06 0.01208 7.7980693777524097e-07 0.012090000000000002 1.8179097115813807e-06 0.012100000000000001 -1.3038964937143207e-06 0.012110000000000001 9.9213025519233763e-07 0.012120000000000001 -6.6365796452976786e-06 0.01213 -6.8125420315060828e-06 0.012140000000000001 -6.1325308268102547e-07 0.012150000000000001 -1.1874899591608225e-06 0.012160000000000001 6.6599398228568223e-06 0.01217 9.5765432924863244e-06 0.012180000000000002 -5.40328485191972e-06 0.012190000000000001 7.5832114864633194e-07 0.012200000000000001 6.568980679444639e-06 0.01221 1.0292925152844573e-06 0.012220000000000002 -7.0013857405987624e-06 0.012230000000000001 1.2730091844394087e-06 0.012240000000000001 4.0637184256546158e-06 0.01225 2.4585129913479616e-06 0.012260000000000002 1.7807682871979059e-06 0.012270000000000001 3.1173974560968557e-07 0.012280000000000001 6.1822446757599226e-06 0.012290000000000001 -8.0628561394611677e-06 0.0123 -7.2289791406304211e-06 0.012310000000000001 4.3378695830963821e-06 0.012320000000000001 -1.1532358644952721e-06 0.012330000000000001 -8.9306807640090336e-06 0.01234 -1.7164991877587741e-07 0.012350000000000002 5.9378696302053958e-06 0.012360000000000001 -2.7675862103849745e-06 0.012370000000000001 1.8314717499142957e-06 0.01238 2.3680522684207938e-08 0.012390000000000002 8.9086473026246415e-06 0.012400000000000001 -3.6754752119819943e-06 0.012410000000000001 -4.5038306585883669e-06 0.01242 -2.3849301370043827e-06 0.012430000000000002 -3.9452302568210744e-06 0.012440000000000001 6.4260753529854328e-06 0.012450000000000001 -1.8395645145038488e-06 0.012460000000000001 8.3007508565397995e-06 0.01247 -2.0367365455705032e-06 0.012480000000000002 -5.8835358335725489e-06 0.012490000000000001 7.5347982155979081e-06 0.012500000000000001 -6.9399338731388945e-06 0.01251 -5.4827099469974072e-07 0.012520000000000002 1.2565749324174452e-05 0.012530000000000001 4.0692138035477857e-06 0.012540000000000001 -1.5049064623807942e-06 0.01255 4.5895248499200731e-06 0.012560000000000002 -1.7959723162422599e-06 0.012570000000000001 -1.4340912466000762e-06 0.012580000000000001 1.8963345234014294e-06 0.01259 3.2845500922758262e-06 0.012600000000000002 -4.551822087836874e-06 0.012610000000000001 2.6600199937551637e-06 0.012620000000000001 4.5442143652498586e-06 0.012630000000000001 5.6945398663076346e-06 0.01264 -3.0517708389981898e-06 0.012650000000000002 4.9340978733213322e-06 0.012660000000000001 1.7886651772537314e-06 0.012670000000000001 1.5675877471836631e-05 0.01268 -5.1232216721790003e-06 0.012690000000000002 3.0241035283171525e-06 0.012700000000000001 -2.0300707425763083e-06 0.012710000000000001 -5.4885621175991497e-08 0.01272 -1.6034027265317032e-06 0.012730000000000002 5.0035647180102749e-07 0.012740000000000001 -5.8090581693625362e-06 0.012750000000000001 -1.7416409801864163e-06 0.012760000000000001 -2.0623985399063721e-06 0.012770000000000002 2.5836798368578992e-06 0.012780000000000001 1.6645870533046211e-06 0.012790000000000001 7.8051730965649617e-06 0.012800000000000001 7.5925375790186885e-07 0.01281 6.4849757377126784e-06 0.012820000000000002 1.1536088964539281e-06 0.012830000000000001 -3.0675360283894739e-06 0.012840000000000001 -4.5922520276460521e-06 0.01285 5.7335299105555542e-06 0.012860000000000002 4.9319523547382851e-06 0.012870000000000001 9.2924357766077905e-06 0.012880000000000001 -8.324053246300337e-07 0.01289 -4.9848750470016417e-06 0.012900000000000002 -2.8145217482686789e-06 0.012910000000000001 4.198105748357385e-06 0.012920000000000001 -3.27170443131324e-06 0.012930000000000001 -2.8664315527592391e-06 0.012940000000000002 -1.8013059571578051e-06 0.012950000000000001 -5.8511913559613367e-06 0.012960000000000001 -4.9334263558973978e-07 0.012970000000000001 2.111702889548294e-06 0.01298 4.9156467531185936e-06 0.012990000000000002 4.9478748520627418e-06 0.013000000000000001 -1.6649352192832647e-06 0.013010000000000001 -1.4434233506160232e-06 0.01302 8.7863920026411106e-06 0.013030000000000002 -2.9211463047098438e-06 0.013040000000000001 -5.9383187862732043e-06 0.013050000000000001 -1.3565141112318567e-06 0.01306 8.1873364311756374e-06 0.013070000000000002 2.5594504157973049e-06 0.013080000000000001 -2.3703314757518221e-06 0.013090000000000001 -1.1623389750884899e-06 0.013100000000000001 -9.7567163652366543e-06 0.013110000000000002 4.3714342638802507e-06 0.013120000000000001 -5.0155577067745367e-06 0.013130000000000001 -1.1290632763437282e-06 0.013140000000000001 2.3391955813045193e-06 0.01315 -1.5806462187745865e-06 0.013160000000000002 -3.4961195615110226e-06 0.013170000000000001 3.0956437760601826e-06 0.013180000000000001 1.0745324438666165e-05 0.01319 5.5147272426192601e-06 0.013200000000000002 5.7112010329626953e-06 0.013210000000000001 1.9208092897082657e-06 0.013220000000000001 -8.2700654795341098e-06 0.01323 2.2295520810485781e-06 0.013240000000000002 4.0418525672356215e-06 0.013250000000000001 2.3356908716071278e-06 0.013260000000000001 -1.2040513400918401e-06 0.013270000000000001 -9.1872299183607706e-07 0.013280000000000002 -2.9273912304925521e-06 0.013290000000000001 -4.3449207408014303e-06 0.013300000000000001 1.5175873837246723e-07 0.013310000000000001 5.5420530185723032e-06 0.01332 1.0979650591863082e-06 0.013330000000000002 4.7851362335932015e-06 0.013340000000000001 1.346834855828829e-06 0.013350000000000001 7.6943989445813644e-06 0.01336 -6.4648786772976315e-06 0.013370000000000002 -6.0641612003160798e-06 0.013380000000000001 3.9303202075848555e-06 0.013390000000000001 -7.0053373982171903e-06 0.0134 -1.8968757121619984e-06 0.013410000000000002 -5.2412108402839503e-06 0.013420000000000001 -3.6902669709713946e-06 0.013430000000000001 -4.2019190633646076e-06 0.013440000000000001 -9.4568985692791569e-06 0.013450000000000002 2.3679795327392822e-06 0.013460000000000001 1.1367389163155323e-05 0.013470000000000001 -9.9883421060385948e-06 0.013480000000000001 -5.2891885898920446e-08 0.01349 2.3774064819653186e-06 0.013500000000000002 5.6210056013934345e-06 0.013510000000000001 4.8806393667684971e-06 0.013520000000000001 7.0385422559866453e-06 0.01353 2.7414907215269888e-06 0.013540000000000002 -4.2981574645586348e-06 0.013550000000000001 -9.1518949744098796e-07 0.013560000000000001 3.1661359276892456e-06 0.01357 -3.885578516498684e-06 0.013580000000000002 -7.1770590149451745e-06 0.013590000000000001 7.0903431392369183e-07 0.013600000000000001 1.1565674890330214e-06 0.013610000000000001 9.6412064032052993e-06 0.013620000000000002 1.8844536907712094e-06 0.013630000000000001 -1.031117803355735e-05 0.013640000000000001 -2.1347991956662944e-07 0.013650000000000001 -1.026039932161791e-05 0.01366 -6.1480951888897117e-07 0.013670000000000002 -3.0784380731891327e-06 0.013680000000000001 1.6217174278979323e-06 0.013690000000000001 1.5655147079030362e-06 0.0137 8.5665796334062162e-06 0.013710000000000002 3.6589173140969846e-06 0.013720000000000001 9.2337313000583223e-06 0.013730000000000001 -3.7305022542390192e-06 0.01374 6.2443266564452029e-06 0.013750000000000002 2.575470512267335e-06 0.013760000000000001 -1.8420597489224801e-06 0.013770000000000001 -1.7915434486240828e-06 0.013780000000000001 -1.0318736736158818e-05 0.013790000000000002 5.4689292594630363e-06 0.013800000000000002 -6.4436951435934233e-06 0.013810000000000001 -7.9526089440588035e-07 0.013820000000000001 -6.2302389900804726e-06 0.01383 -4.5716636865676014e-06 0.013840000000000002 -2.4048925310113737e-06 0.013850000000000001 -4.0392768917863538e-06 0.013860000000000001 -3.078323255772453e-06 0.01387 3.0464279866206725e-06 0.013880000000000002 1.2788380800603233e-07 0.013890000000000001 1.4957756483430546e-06 0.013900000000000001 -3.2936369037640591e-06 0.01391 -3.8291598579437278e-06 0.013920000000000002 1.325582906384408e-06 0.013930000000000001 -1.2060162498236876e-05 0.013940000000000001 -8.7210244142094897e-06 0.013950000000000001 -3.6585675456174154e-06 0.013960000000000002 -1.6918204519083486e-06 0.013970000000000002 5.4666017348210663e-06 0.013980000000000001 -9.0298900709252184e-07 0.013990000000000001 -9.0866103372378899e-07 0.014 -1.1527765185152238e-05 0.014010000000000002 9.2018998931554214e-08 0.014020000000000001 -1.7186154190510431e-06 0.014030000000000001 -1.1146427936918416e-05 0.01404 3.9189557293198912e-06 0.014050000000000002 2.7142624933730128e-06 0.014060000000000001 2.6167700038356152e-06 0.014070000000000001 7.8639605191738561e-06 0.014080000000000001 -1.0132003665359122e-05 0.014090000000000002 -5.776491827191619e-06 0.014100000000000001 -4.5778525262794139e-06 0.014110000000000001 -9.6906780365909289e-06 0.014120000000000001 2.6510659883744879e-06 0.014130000000000002 6.99469121042192e-06 0.014140000000000002 -5.0228175591135002e-06 0.014150000000000001 5.8992801705179338e-06 0.014160000000000001 -9.4364856917575093e-07 0.01417 -1.9015779169187015e-06 0.014180000000000002 -1.4131462390777755e-05 0.014190000000000001 -1.3694811556510839e-05 0.014200000000000001 6.6238681386218192e-06 0.01421 3.9028767637465672e-06 0.014220000000000002 7.0654807757206808e-06 0.014230000000000001 3.0272386887219634e-07 0.014240000000000001 9.7296617195229106e-06 0.014250000000000001 1.743065630659072e-06 0.014260000000000002 9.7741702893896246e-06 0.014270000000000001 -5.4598290008105148e-06 0.014280000000000001 -4.2220184852019695e-06 0.014290000000000001 5.8699988602008004e-06 0.014300000000000002 3.178781965745913e-06 0.014310000000000002 5.5101855731010691e-06 0.014320000000000001 -9.2756199623471556e-06 0.014330000000000001 1.0987374340405761e-06 0.01434 1.5168257053319615e-06 0.014350000000000002 -2.5517018708757358e-06 0.014360000000000001 -6.5782550846169012e-06 0.014370000000000001 -1.4801514416716012e-06 0.01438 -6.6815729430892666e-06 0.014390000000000002 1.2138082975418607e-07 0.014400000000000001 6.100892114098816e-06 0.014410000000000001 7.0292073859955597e-06 0.014420000000000001 -5.6234324298507082e-06 0.014430000000000002 4.9440286048615549e-07 0.014440000000000001 -7.0767157969500953e-06 0.014450000000000001 4.5209352131546029e-06 0.014460000000000001 4.3588606139238242e-06 0.014470000000000002 2.8564916131026981e-06 0.014480000000000002 3.8551038761257783e-06 0.014490000000000001 -4.0164149394660997e-06 0.014500000000000001 -2.322072035534527e-06 0.01451 -8.9350687111379231e-06 0.014520000000000002 -2.3837033472226076e-06 0.014530000000000001 -1.2419840372943608e-05 0.014540000000000001 -6.3285213876884136e-06 0.01455 -4.7254376433271537e-06 0.014560000000000002 6.6997197853578846e-06 0.014570000000000001 -5.8769430113685668e-06 0.014580000000000001 -3.040668563198237e-06 0.014590000000000001 -4.4907045663791098e-06 0.014600000000000002 4.9254250080185741e-06 0.014610000000000001 1.9548750492800369e-06 0.014620000000000001 9.8490409438150842e-07 0.014630000000000001 -2.4249360532357887e-07 0.014640000000000002 4.649016520778888e-06 0.014650000000000002 1.8776718465257582e-06 0.014660000000000001 -1.7322293987105023e-06 0.014670000000000001 8.2275905631554657e-06 0.01468 -3.9718281747595986e-06 0.014690000000000002 4.4224844999735147e-06 0.014700000000000001 -3.6014626412570674e-06 0.014710000000000001 -3.5707894948986367e-06 0.01472 -7.8717659492107979e-07 0.014730000000000002 -1.1789687924987063e-06 0.014740000000000001 -1.0384466356935141e-06 0.014750000000000001 -5.3897172982971909e-06 0.014760000000000001 7.9216961787113004e-06 0.014770000000000002 -4.0851119669231936e-06 0.014780000000000001 5.6978766853026213e-06 0.014790000000000001 -3.5800791162450287e-06 0.014800000000000001 2.7622696492989811e-07 0.014810000000000002 3.9821398123935836e-06 0.014820000000000002 6.6788058326886771e-07 0.014830000000000001 5.4364911349803434e-07 0.014840000000000001 -9.3239935180387149e-06 0.01485 -2.7052268953682609e-06 0.014860000000000002 5.1752599773058206e-06 0.014870000000000001 -3.2925933451786277e-06 0.014880000000000001 2.8791849731198e-06 0.01489 -4.9936069198885479e-06 0.014900000000000002 6.3360766052979624e-06 0.014910000000000001 -4.2250969824642366e-06 0.014920000000000001 -6.3738769170783087e-07 0.014930000000000001 5.9904849823074565e-06 0.014940000000000002 2.1353201088639865e-06 0.014950000000000001 5.1491816671601302e-06 0.014960000000000001 -8.130580433844033e-06 0.014970000000000001 -1.9293871775060425e-06 0.014980000000000002 1.0151161909828221e-05 0.014990000000000002 -7.0838485248426395e-06 0.015000000000000001 2.2507848132866194e-06 0.015010000000000001 -3.351334710379638e-06 0.01502 2.0678924581032712e-06 0.015030000000000002 -6.1345064530185652e-06 0.015040000000000001 1.3822743428501608e-05 0.015050000000000001 1.2856415297763471e-05 0.01506 3.5094985191439323e-06 0.015070000000000002 9.3556210640004631e-07 0.015080000000000001 1.3678960253177814e-08 0.015090000000000001 -2.6116456793103229e-07 0.015100000000000001 -2.159708603711549e-06 0.015110000000000002 -1.0671631296786984e-06 0.015120000000000001 -3.3487533492341882e-06 0.015130000000000001 5.4622827762214318e-06 0.015140000000000001 -8.4166460536666769e-06 0.015150000000000002 7.0329457499885424e-06 0.015160000000000002 -3.1696567572379189e-06 0.015170000000000001 -3.4180518389389087e-07 0.015180000000000001 -5.8150144666529675e-06 0.01519 -1.1855252717068685e-06 0.015200000000000002 -3.6897721486020393e-06 0.015210000000000001 9.3234297001666488e-06 0.015220000000000001 -4.4953745659214636e-06 0.01523 5.17100630465646e-06 0.015240000000000002 -2.44977544299857e-06 0.015250000000000001 -1.9793940836797294e-06 0.015260000000000001 -8.1238183634960384e-06 0.015270000000000001 -2.8525914239683043e-06 0.015280000000000002 3.4567344366131869e-07 0.015290000000000002 2.3844022525372104e-06 0.015300000000000001 4.3746353682314732e-07 0.015310000000000001 3.2779750521042682e-07 0.015320000000000002 -1.1832193239329782e-05 0.015330000000000002 -6.0495487911071329e-07 0.015340000000000001 -3.5463650445888555e-06 0.015350000000000001 6.1256679343324651e-06 0.015360000000000002 -8.9348575835832971e-06 0.015370000000000002 1.4669236967301817e-06 0.015380000000000001 -2.3828975548695512e-06 0.015390000000000001 7.2944157867159219e-06 0.0154 2.1426530915341644e-06 0.015410000000000002 6.5677884406007501e-06 0.015420000000000001 6.3506944617145025e-07 0.015430000000000001 -2.7181044860510586e-06 0.015440000000000001 3.831487358327361e-06 0.015450000000000002 -5.9438552339930509e-06 0.015460000000000002 -1.1848248844691195e-05 0.015470000000000001 8.6535339552503862e-06 0.015480000000000001 7.8458015444015512e-06 0.015490000000000002 6.8093434200027801e-07 0.015500000000000002 4.6673416611849899e-06 0.015510000000000001 -5.8413959931133354e-06 0.015520000000000001 1.169657472205691e-06 0.015530000000000002 3.3096700764395213e-06 0.015540000000000002 -6.4038062950821339e-07 0.015550000000000001 -9.1778755256831523e-06 0.015560000000000001 2.0285912561197997e-06 0.015570000000000001 -6.4217290956453985e-06 0.015580000000000002 2.8042760942834395e-06 0.015590000000000001 -8.4363437949666544e-07 0.015600000000000001 1.933040652281049e-06 0.015610000000000001 -6.3309333052898401e-06 0.015620000000000002 2.6534013642323612e-06 0.015630000000000002 9.785389459620419e-06 0.015640000000000001 2.7358819605347337e-06 0.015650000000000001 -1.8550871619826888e-06 0.01566 2.1738603866903185e-07 0.01567 -1.1740641012546252e-05 0.015680000000000003 3.7034936157459781e-06 0.015690000000000003 2.1307079022654239e-08 0.015700000000000002 -8.9261716719069406e-06 0.015710000000000002 1.4615322646239472e-06 0.015720000000000001 6.5852618058386995e-06 0.015730000000000001 -4.2812456334497976e-08 0.015740000000000001 4.6915406347105409e-06 0.01575 1.9696519914519268e-06 0.01576 -7.9352982767470695e-07 0.015770000000000003 5.6845068987918468e-06 0.015780000000000002 2.3307980697087759e-06 0.015790000000000002 -1.248334647697956e-06 0.015800000000000002 5.8392575222436084e-06 0.015810000000000001 8.9142130833568264e-06 0.015820000000000001 4.2326393311179852e-07 0.01583 6.7784777776720145e-06 0.01584 -6.0769514423760753e-06 0.015850000000000003 8.2805155198215542e-07 0.015860000000000003 2.7845015451554574e-06 0.015870000000000002 3.1871113021724861e-06 0.015880000000000002 6.3080146768310713e-06 0.015890000000000001 1.2562726343443556e-05 0.015900000000000001 -4.2532013961845891e-07 0.015910000000000001 -1.6131640211685495e-06 0.01592 4.8123289918828873e-06 0.01593 -1.3236405358608555e-05 0.015940000000000003 3.4093621988892183e-07 0.015950000000000002 -3.5638650195425534e-07 0.015960000000000002 4.4576573562276185e-06 0.015970000000000002 3.6227551105018427e-06 0.015980000000000001 4.3817802409047545e-06 0.015990000000000001 3.7532495600655948e-06 0.016 1.3042953636670092e-06 0.01601 -4.5232986579086403e-06 0.016020000000000003 -2.2203234816804904e-08 0.016030000000000003 -4.9859205934508448e-07 0.016040000000000002 7.0652917307838623e-06 0.016050000000000002 -3.7599657882001382e-06 0.016060000000000001 -1.6069718333013199e-06 0.016070000000000001 2.2382259105098831e-06 0.016080000000000001 3.104376220538295e-06 0.01609 -9.9855090297530716e-06 0.0161 9.324468912523342e-08 0.016110000000000003 -1.7173867336935105e-06 0.016120000000000002 -4.1888310510726904e-06 0.016130000000000002 -4.8004119790030647e-06 0.016140000000000002 4.1645055285272664e-06 0.016150000000000001 -1.2086982435409305e-06 0.016160000000000001 1.0281227773742271e-07 0.01617 8.8949691165090216e-06 0.01618 3.630034606512567e-07 0.016190000000000003 -3.5431013075476608e-06 0.016200000000000003 -3.252665947252232e-06 0.016210000000000002 2.6326887825433208e-06 0.016220000000000002 -4.0650618854090144e-06 0.016230000000000001 -1.0679980047366177e-06 0.016240000000000001 -5.0014459167547481e-06 0.016250000000000001 -1.1058401557654361e-05 0.01626 4.3253638512943469e-06 0.01627 -6.8684686766830692e-06 0.016280000000000003 1.0434093525490822e-06 0.016290000000000002 -7.4272485429337902e-06 0.016300000000000002 -4.3772095571192216e-06 0.016310000000000002 -4.0388431009720112e-06 0.016320000000000001 6.348815053367572e-06 0.016330000000000001 2.8434270249819458e-06 0.01634 -1.954360932611554e-06 0.01635 5.3687706896965699e-07 0.016360000000000003 -1.0004856290357573e-05 0.016370000000000003 3.9746218914690741e-06 0.016380000000000002 -1.7211494839252193e-06 0.016390000000000002 4.5614715469739221e-06 0.016400000000000001 3.0568207500535442e-08 0.016410000000000001 2.0420515093096825e-06 0.016420000000000001 6.0758908716857013e-06 0.01643 -1.0216514334625109e-05 0.01644 -2.0431297233500676e-06 0.016450000000000003 -8.8898800299709103e-06 0.016460000000000002 -2.1938883083041037e-06 0.016470000000000002 -9.7558502141345021e-06 0.016480000000000002 2.7952900969970431e-06 0.016490000000000001 -7.8189778931585584e-07 0.016500000000000001 1.2355850739924429e-06 0.01651 -6.5362716280839998e-06 0.01652 -9.1603788050999692e-07 0.016530000000000003 7.3892617703752175e-06 0.016540000000000003 2.1252277834264009e-07 0.016550000000000002 -6.1405777191941648e-06 0.016560000000000002 -9.4895661306445069e-06 0.016570000000000001 -1.0634194596132973e-05 0.016580000000000001 3.483002476435009e-06 0.016590000000000001 -6.7184929569153178e-06 0.0166 7.7203709224755489e-06 0.01661 5.4961105095712167e-06 0.016620000000000003 3.675952025424274e-07 0.016630000000000002 8.0985612430922342e-06 0.016640000000000002 -7.1805148119830145e-06 0.016650000000000002 -2.5954936161558792e-06 0.016660000000000001 2.3696179018859382e-06 0.016670000000000001 -7.0027756449116703e-06 0.01668 -4.989613859841407e-07 0.01669 -5.9126837796132344e-07 0.016700000000000003 -2.4024782309465795e-06 0.016710000000000003 4.1986114393096621e-06 0.016720000000000002 5.1138906409185227e-07 0.016730000000000002 -1.8648710666291375e-06 0.016740000000000001 -8.3752230679208195e-06 0.016750000000000001 5.2487941845541879e-06 0.016760000000000001 3.3941133245250794e-06 0.01677 -4.7930378225795652e-06 0.01678 8.3742465017297301e-06 0.016790000000000003 -1.5700570853607579e-07 0.016800000000000002 -7.2009065035241352e-07 0.016810000000000002 1.1870132347708353e-06 0.016820000000000002 9.191663235106094e-07 0.016830000000000001 1.5828104273899063e-06 0.016840000000000001 -1.2285154328219562e-07 0.01685 -3.7089093518244717e-06 0.01686 2.4180716275815693e-06 0.016870000000000003 4.1713967748042027e-06 0.016880000000000003 -3.1423511605199843e-06 0.016890000000000002 -4.9538315772514184e-06 0.016900000000000002 5.9243573748229477e-06 0.016910000000000001 -4.6027401522874296e-06 0.016920000000000001 5.0380912595219144e-06 0.016930000000000001 -5.908584254594808e-06 0.01694 -4.2881841424550839e-06 0.01695 -9.335604833738811e-06 0.016960000000000003 1.9769486776306854e-06 0.016970000000000002 -2.8392847673746155e-06 0.016980000000000002 -6.1847597201460726e-07 0.016990000000000002 4.4672498065071997e-06 0.017000000000000001 -3.0165003964698399e-06 0.017010000000000001 4.2249080214118352e-06 0.01702 -1.7486851355988843e-06 0.01703 -2.4684916607136612e-06 0.017040000000000003 4.7980692157610334e-06 0.017050000000000003 -2.7585170423698774e-06 0.017060000000000002 1.3365937791887823e-06 0.017070000000000002 -7.405733095404695e-06 0.017080000000000001 1.4057456098023766e-06 0.017090000000000001 2.1155048294298895e-06 0.017100000000000001 -1.2967631766076594e-06 0.01711 -2.071131950282591e-06 0.01712 3.6058727924388152e-06 0.017130000000000003 -2.1124616573341844e-06 0.017140000000000002 -2.076555089007237e-07 0.017150000000000002 -2.0292342021424567e-06 0.017160000000000002 8.5487504252460134e-06 0.017170000000000001 3.3460923374945885e-06 0.017180000000000001 3.9866342347268351e-06 0.01719 9.5809955747839185e-06 0.0172 2.8961590466057236e-06 0.017210000000000003 2.1463508471457396e-06 0.017220000000000003 -5.2661393936134894e-06 0.017230000000000002 1.08524160608794e-06 0.017240000000000002 2.5220474651414743e-06 0.017250000000000001 -2.1974295460113e-06 0.017260000000000001 -2.8388292189228591e-06 0.017270000000000001 -4.6501103047069844e-06 0.01728 -2.7308983644096848e-06 0.01729 -1.4117344394901835e-06 0.017300000000000003 1.1114699096505182e-07 0.017310000000000002 8.859363674390706e-07 0.017320000000000002 -4.1830811412230457e-06 0.017330000000000002 4.1985782740493571e-06 0.017340000000000001 1.960670727512809e-07 0.017350000000000001 1.7304974383085671e-06 0.01736 -6.0216904892587957e-06 0.01737 2.3093055620362625e-06 0.017380000000000003 -3.0793668287216682e-07 0.017390000000000003 9.2419930381446225e-06 0.017400000000000002 1.1045054808108856e-07 0.017410000000000002 -1.239820526115918e-06 0.017420000000000001 2.5705544780953275e-06 0.017430000000000001 -3.5720440913872112e-06 0.017440000000000001 1.0481810681692826e-06 0.01745 -6.0404540108812207e-06 0.01746 3.5863003153943356e-06 0.017470000000000003 7.1839347295190296e-06 0.017480000000000002 -5.4948103990856609e-06 0.017490000000000002 -1.6196297282149786e-06 0.017500000000000002 4.3891391990180177e-06 0.017510000000000001 4.7071853427575185e-06 0.017520000000000001 3.0078171873520539e-07 0.01753 3.249560171584345e-06 0.01754 1.0712220767473282e-05 0.017550000000000003 -5.2871483387218181e-06 0.017560000000000003 4.9980457290744885e-06 0.017570000000000002 5.3820448545525905e-06 0.017580000000000002 4.1492687020602854e-06 0.017590000000000001 4.5648013392530712e-06 0.017600000000000001 2.3540713048196743e-06 0.017610000000000001 -1.1636683989258114e-06 0.01762 -1.8707770890837656e-06 0.01763 -6.2066547535428921e-06 0.017640000000000003 2.4620723264632838e-07 0.017650000000000002 9.1987286156531961e-06 0.017660000000000002 -4.5785737744722738e-06 0.017670000000000002 8.7627582418057026e-06 0.017680000000000001 -6.7705444993189447e-06 0.017690000000000001 -4.4016060686671155e-07 0.0177 -5.7846355617369511e-06 0.01771 1.6716924574440402e-06 0.017720000000000003 -6.1858771824250021e-06 0.017730000000000003 -4.0563658379334611e-06 0.017740000000000002 1.951371038465159e-06 0.017750000000000002 -7.0938123595599373e-06 0.017760000000000001 1.3498671986313242e-06 0.017770000000000001 -6.8883486982247772e-06 0.017780000000000001 3.1480872221990809e-07 0.01779 1.607918566764365e-06 0.0178 6.5732438235393095e-06 0.017810000000000003 -5.1818636917732471e-06 0.017820000000000003 -4.8951111220546881e-06 0.017830000000000002 3.3992198068476391e-06 0.017840000000000002 1.0482801827169882e-05 0.017850000000000001 3.0165970006006516e-06 0.017860000000000001 -7.4718673385131693e-06 0.01787 1.7625042107721922e-06 0.01788 1.5898283425713357e-06 0.017890000000000003 -5.4418124028222259e-06 0.017900000000000003 4.2891459581889394e-06 0.017910000000000002 -8.4852498629910662e-07 0.017920000000000002 -1.018150700534507e-06 0.017930000000000001 -7.8329844551403409e-06 0.017940000000000001 7.5793304987183135e-06 0.017950000000000001 7.96263115139881e-06 0.01796 1.4069737734002511e-06 0.01797 7.8719748192034366e-06 0.017980000000000003 -1.7732353911338401e-06 0.017990000000000003 -5.0007586847944577e-06 0.018000000000000002 -1.1724121758378799e-06 0.018010000000000002 4.8339258612438296e-06 0.018020000000000001 -1.1132527733805195e-06 0.018030000000000001 -4.0897969500757802e-06 0.01804 -1.6574882490113226e-06 0.01805 8.2868006889589166e-06 0.018060000000000003 -1.0863753839354609e-06 0.018070000000000003 5.0502324359429158e-06 0.018080000000000002 -4.074517821230691e-06 0.018090000000000002 6.2686855859976044e-06 0.018100000000000002 -6.153624149641957e-06 0.018110000000000001 -4.3898613879615398e-06 0.018120000000000001 -6.624134718475934e-06 0.01813 -1.2843444659428417e-06 0.01814 -7.2655275013259229e-07 0.018150000000000003 1.7186813476051936e-06 0.018160000000000003 1.4225372794077767e-06 0.018170000000000002 -3.7428374872034672e-06 0.018180000000000002 3.177319966393234e-06 0.018190000000000001 -1.011575471983199e-05 0.018200000000000001 -2.2834624231398693e-06 0.01821 -4.5377054551078605e-07 0.01822 5.9187081655276224e-06 0.018230000000000003 -1.4128800971522042e-06 0.018240000000000003 2.1550759233268699e-06 0.018250000000000002 4.1605739398023569e-08 0.018260000000000002 7.1936288303330184e-06 0.018270000000000002 3.4148124146906161e-07 0.018280000000000001 -6.6171817437141651e-06 0.018290000000000001 5.3662058197994352e-06 0.0183 -1.3473797956984308e-06 0.01831 4.6711288707796413e-06 0.018320000000000003 3.4142058926253128e-06 0.018330000000000003 -7.1072787556177071e-06 0.018340000000000002 -4.5068245501864143e-06 0.018350000000000002 -1.0251288528655214e-05 0.018360000000000001 -4.9763621889152377e-06 0.018370000000000001 -2.8969872542035917e-06 0.018380000000000001 6.965015955023798e-06 0.01839 -6.6944273757199277e-06 0.018400000000000003 4.0629703023235869e-06 0.018410000000000003 -1.0001958342918824e-06 0.018420000000000002 1.0996237315316383e-05 0.018430000000000002 1.117768125648294e-06 0.018440000000000002 -4.1377717093293927e-06 0.018450000000000001 3.3012116936810439e-06 0.018460000000000001 -4.978138190930196e-06 0.01847 3.7568470037298126e-06 0.01848 -3.0510140623424818e-06 0.018490000000000003 -4.0326177273277219e-06 0.018500000000000003 7.8697530169083753e-06 0.018510000000000002 -6.6389900367899372e-06 0.018520000000000002 7.9958303209481895e-06 0.018530000000000001 8.2986468521881063e-07 0.018540000000000001 -7.3153735524309008e-07 0.018550000000000001 -1.9134499632931448e-06 0.01856 -1.8434874144845817e-07 0.018570000000000003 1.2480282639683568e-05 0.018580000000000003 3.3482952228738729e-06 0.018590000000000002 5.7482461916999895e-06 0.018600000000000002 -2.9591068856622958e-07 0.018610000000000002 -1.7906524088334091e-06 0.018620000000000001 8.1807380460483635e-06 0.018630000000000001 2.7920818839853618e-06 0.01864 2.3057285787358606e-06 0.01865 2.5484891435723806e-07 0.018660000000000003 2.7715437975331429e-06 0.018670000000000003 -2.1761448711330045e-06 0.018680000000000002 -1.172814856043606e-06 0.018690000000000002 6.9725823736096859e-07 0.018700000000000001 5.9735800685849427e-07 0.018710000000000001 -8.2563860673601506e-06 0.018720000000000001 2.562607787473274e-06 0.01873 -3.8359279803837909e-06 0.018740000000000003 -2.530124828528006e-06 0.018750000000000003 -6.3810133343366675e-06 0.018760000000000002 3.4984401155971482e-06 0.018770000000000002 -5.7053741124689523e-07 0.018780000000000002 -3.1218863010652938e-06 0.018790000000000001 -2.8802120503933768e-06 0.018800000000000001 5.0507941982137178e-06 0.01881 -1.9643979292266705e-06 0.01882 -1.6384359760664371e-07 0.018830000000000003 -7.2756934277721193e-06 0.018840000000000003 -5.70920208096256e-06 0.018850000000000002 -4.6357049895790272e-06 0.018860000000000002 3.1500058227090509e-06 0.018870000000000001 1.6406380998348505e-08 0.018880000000000001 -5.0209835761342518e-06 0.018890000000000001 -9.4842419830038499e-06 0.0189 -1.4316451517712318e-07 0.018910000000000003 1.1960135491269332e-06 0.018920000000000003 5.5617582076009635e-06 0.018930000000000002 -4.0572996930580003e-07 0.018940000000000002 -3.6821895380283523e-06 0.018950000000000002 -1.9411994385873695e-06 0.018960000000000001 -8.4038047201964558e-07 0.018970000000000001 2.3373837357463629e-06 0.01898 -2.9745763782369282e-06 0.01899 4.9810609106921254e-06 0.019000000000000003 2.1160351253828521e-06 0.019010000000000003 -1.2417785085575475e-06 0.019020000000000002 -2.7061145339079536e-06 0.019030000000000002 1.2305431306493956e-05 0.019040000000000001 1.128125685938379e-06 0.019050000000000001 -8.6299058527051276e-06 0.019060000000000001 2.5275186280347251e-06 0.01907 9.210083107941012e-06 0.019080000000000003 -2.6569842138984215e-06 0.019090000000000003 1.6453661374908516e-06 0.019100000000000002 -7.6446814566852686e-06 0.019110000000000002 1.1986790492029654e-06 0.019120000000000002 7.7450533581269662e-06 0.019130000000000001 -1.0316599457836322e-06 0.019140000000000001 1.7035356317750629e-06 0.01915 1.0560378212533053e-05 0.01916 -3.8592880022065726e-06 0.019170000000000003 -3.0015307234399516e-06 0.019180000000000003 -6.1236080387294036e-06 0.019190000000000002 8.1777632012686252e-06 0.019200000000000002 7.4909611846494843e-06 0.019210000000000001 -8.6695301346438704e-06 0.019220000000000001 -6.7514576191268569e-06 0.019230000000000001 1.7455333569132551e-07 0.01924 -4.0008811986809271e-06 0.019250000000000003 6.1770304681892969e-06 0.019260000000000003 1.3908638282451904e-07 0.019270000000000002 4.1548199125522345e-07 0.019280000000000002 -1.0565582687787528e-05 0.019290000000000002 8.9304612422360648e-06 0.019300000000000001 7.5964613876392882e-07 0.019310000000000001 1.0197209793409117e-05 0.01932 -1.6877639814702731e-07 0.01933 1.8373412286794928e-06 0.019340000000000003 -3.8390893497121332e-06 0.019350000000000003 -6.1363118241603744e-06 0.019360000000000002 8.7754051870535333e-07 0.019370000000000002 -1.7076087805140527e-06 0.019380000000000001 7.4654443723606295e-06 0.019390000000000001 -3.2140257743786103e-06 0.019400000000000001 -5.6949362631130512e-06 0.01941 2.2741335276160514e-06 0.019420000000000003 2.4691237174259671e-06 0.019430000000000003 1.7797532589474546e-06 0.019440000000000002 -5.586626545933596e-07 0.019450000000000002 4.77915402294839e-06 0.019460000000000002 -5.0071273470601521e-06 0.019470000000000001 1.7382040443391154e-06 0.019480000000000001 -1.3226178173933324e-06 0.01949 8.4237379891400408e-06 0.0195 -7.3905395799423255e-07 0.019510000000000003 2.7373959466849559e-06 0.019520000000000003 7.0193137762674243e-06 0.019530000000000002 -8.5210305713246739e-06 0.019540000000000002 -3.8865604254984671e-06 0.019550000000000001 -1.9116545861163595e-07 0.019560000000000001 -2.8787213364012663e-07 0.019570000000000001 6.8085183959638354e-06 0.01958 -9.3217126504117639e-06 0.019590000000000003 5.8827336196416e-06 0.019600000000000003 8.9711340438692467e-06 0.019610000000000002 -5.3335643793263462e-06 0.019620000000000002 -5.5174789358122102e-06 0.019630000000000002 2.398618577213967e-06 0.019640000000000001 -1.4677077510757648e-06 0.019650000000000001 -1.1619911508652816e-06 0.01966 -1.2461637279084058e-06 0.01967 -2.3512618522998898e-06 0.019680000000000003 -3.4884043340638017e-06 0.019690000000000003 -3.0735809251489019e-06 0.019700000000000002 -2.8902631174734131e-06 0.019710000000000002 1.6541669992762579e-06 0.019720000000000001 -1.1710901499244042e-05 0.019730000000000001 5.5596366876439414e-06 0.019740000000000001 4.4725119938788515e-06 0.01975 1.5322505165041074e-07 0.019760000000000003 5.4220421451173655e-06 0.019770000000000003 5.1188891581285636e-06 0.019780000000000002 -2.9817983909361466e-06 0.019790000000000002 7.7209772120127277e-06 0.019800000000000002 4.3600667374870972e-06 0.019810000000000001 3.9730006634031363e-06 0.019820000000000001 2.6808168845642221e-07 0.01983 -3.0004627736985433e-06 0.01984 -7.8549492098224521e-06 0.019850000000000003 -4.7791808614960554e-06 0.019860000000000003 9.6760076122352916e-06 0.019870000000000002 6.0955521486397108e-07 0.019880000000000002 -2.3497224632164449e-06 0.019890000000000001 -7.4900857720637885e-06 0.019900000000000001 -1.516671576009401e-06 0.019910000000000001 -3.7374882927190993e-06 0.01992 5.9603897457431233e-06 0.019930000000000003 -1.2891316141946159e-05 0.019940000000000003 -4.1749602703995513e-06 0.019950000000000002 -3.8548423828789141e-06 0.019960000000000002 -4.8467099429068999e-06 0.019970000000000002 -4.319099570687882e-06 0.019980000000000001 -1.3650874183865492e-05 0.019990000000000001 -1.4253025685659101e-06 0.02 -1.7133272990907477e-06 0.02001 3.6245685309083717e-06 0.020020000000000003 3.5204706966722367e-06 0.020030000000000003 9.9770892865198707e-07 0.020040000000000002 6.7583426376077484e-06 0.020050000000000002 -5.9732027802117762e-06 0.020060000000000001 -6.120314316381703e-07 0.020070000000000001 5.1698716571113997e-07 0.020080000000000001 2.9992930287984356e-06 0.02009 2.2537121096766708e-06 0.020100000000000003 -2.5243902503928335e-06 0.020110000000000003 2.7567719286163891e-06 0.020120000000000002 -4.8255871743370923e-06 0.020130000000000002 3.9571356868215122e-07 0.020140000000000002 -6.6545179285781637e-06 0.020150000000000001 5.8781523601655736e-06 0.020160000000000001 5.9993482853665434e-06 0.02017 5.9041045825540941e-06 0.02018 6.3481648601723759e-06 0.020190000000000003 -2.0956297361957736e-06 0.020200000000000003 3.6822922912078618e-07 0.020210000000000002 -4.8653440801810106e-06 0.020220000000000002 2.3340460845839381e-06 0.020230000000000001 -6.3568297789732604e-06 0.020240000000000001 -4.6669094499053012e-06 0.020250000000000001 -2.0995834464540318e-06 0.02026 1.0681059065820711e-06 0.020270000000000003 9.2495867945320583e-06 0.020280000000000003 2.1373786166517165e-06 0.020290000000000002 6.0011398433333598e-06 0.020300000000000002 -9.3302970445703227e-07 0.020310000000000002 8.833425929075634e-07 0.020320000000000001 -2.4783859250765772e-06 0.020330000000000001 -1.060668610867001e-06 0.02034 1.729389739867437e-06 0.02035 3.7027430066701704e-06 0.020360000000000003 -6.9412889578237717e-07 0.020370000000000003 -9.1334035362565923e-06 0.020380000000000002 1.7325180346238985e-06 0.020390000000000002 6.7832245454081184e-06 0.020400000000000001 -7.370064173477682e-06 0.020410000000000001 4.1511387511554123e-06 0.020420000000000001 -1.9123135373673363e-06 0.02043 3.7736716201933911e-06 0.020440000000000003 -3.3476018303173625e-06 0.020450000000000003 -3.1656208583875077e-06 0.020460000000000002 -7.7881057646330142e-06 0.020470000000000002 7.4927649764150915e-06 0.020480000000000002 4.3600891690522035e-06 0.020490000000000001 1.1890237382434835e-06 0.020500000000000001 1.6355826669020059e-06 0.02051 3.2933112422540758e-06 0.02052 4.1031261878166617e-06 0.020530000000000003 -5.6968191018358809e-06 0.020540000000000003 -9.8918597068849752e-07 0.020550000000000002 -4.4769735310301521e-06 0.020560000000000002 2.8352598849653913e-06 0.020570000000000001 -3.2456691989812677e-06 0.020580000000000001 -3.563404923485702e-06 0.020590000000000001 -3.2295378891937273e-06 0.0206 8.8868667522153216e-07 0.020610000000000003 1.8089340192019843e-06 0.020620000000000003 3.8993302342613515e-06 0.020630000000000003 3.7076783054405195e-06 0.020640000000000002 5.9784906454146026e-06 0.020650000000000002 1.0084207214961627e-06 0.020660000000000001 -9.6503049426318939e-07 0.020670000000000001 -3.9323898443841479e-06 0.02068 -1.3814944994923302e-06 0.02069 -2.553662688900634e-06 0.020700000000000003 5.5194476828442089e-06 0.020710000000000003 -1.2859019081325983e-06 0.020720000000000002 4.6592988691763798e-06 0.020730000000000002 -1.2943477368337731e-06 0.020740000000000001 7.2414406835110803e-06 0.020750000000000001 4.8225749087603749e-06 0.020760000000000001 8.6988115754136746e-06 0.02077 7.2250608790515806e-06 0.020780000000000003 -3.2308120566308932e-06 0.020790000000000003 4.0481597278597314e-06 0.020800000000000003 -2.3279447028623684e-06 0.020810000000000002 -1.0230578544887719e-05 0.020820000000000002 4.7152908844828519e-06 0.020830000000000001 -2.1399832523591653e-06 0.020840000000000001 -8.9668474361935362e-07 0.02085 -8.4098257329680182e-06 0.02086 9.4958204482729151e-06 0.020870000000000003 -4.9583375184818493e-07 0.020880000000000003 1.8579155138638653e-07 0.020890000000000002 1.0508167234677629e-06 0.020900000000000002 -1.2842063078946328e-06 0.020910000000000002 4.9695549267447512e-06 0.020920000000000001 1.040812965141946e-06 0.020930000000000001 -5.4143171142599231e-06 0.02094 -7.1849120774730883e-06 0.020950000000000003 9.2338909700092452e-06 0.020960000000000003 3.4246077194739619e-06 0.020970000000000003 -1.0975196910164102e-06 0.020980000000000002 -7.0299353695327101e-06 0.020990000000000002 -2.9008813821557262e-06 0.021000000000000001 -4.0766166823202676e-06 0.021010000000000001 5.1606262151770605e-06 0.02102 2.0092664055757262e-06 0.02103 -9.775041799703444e-06 0.021040000000000003 4.2524959056192686e-06 0.021050000000000003 -1.2453403750102023e-06 0.021060000000000002 -1.3386893889232122e-06 0.021070000000000002 2.4623763032079979e-06 0.021080000000000002 8.7852458017998106e-06 0.021090000000000001 5.6821219346669964e-06 0.021100000000000001 4.2737221080452862e-06 0.02111 -1.0424649412457824e-06 0.021120000000000003 -5.148762054239277e-06 0.021130000000000003 6.2222862300296241e-06 0.021140000000000003 -1.4212903031436832e-06 0.021150000000000002 -1.9516009603518153e-06 0.021160000000000002 4.1404349083675795e-06 0.021170000000000001 -1.2366345139720097e-05 0.021180000000000001 4.9287620970267698e-06 0.021190000000000001 1.8074897637481544e-06 0.0212 9.5865238441546345e-06 0.021210000000000003 -6.7703093028918125e-06 0.021220000000000003 -2.7801641729648781e-07 0.021230000000000002 -1.6161968824057747e-06 0.021240000000000002 -5.121775623266856e-06 0.021250000000000002 -1.6036693303944668e-06 0.021260000000000001 1.9610929911797912e-07 0.021270000000000001 -8.9221890779331802e-07 0.02128 2.711179293626658e-06 0.021290000000000003 3.3999520608656073e-07 0.021300000000000003 3.2529951018267007e-06 0.021310000000000003 -5.2274622503550843e-06 0.021320000000000002 -1.0000020683310898e-06 0.021330000000000002 1.3498383033000107e-06 0.021340000000000001 6.7299122538132779e-06 0.021350000000000001 -7.1038862007376494e-06 0.021360000000000001 -3.6099345657403613e-06 0.02137 -6.5090610399583457e-06 0.021380000000000003 -2.0861622419278202e-06 0.021390000000000003 -8.762002377135038e-07 0.021400000000000002 -9.554238218970404e-07 0.021410000000000002 -9.6320344433652846e-06 0.021420000000000002 -2.3750515270351302e-06 0.021430000000000001 3.9533074504062392e-06 0.021440000000000001 -5.6874604494806262e-06 0.02145 -3.6985816714120979e-07 0.021460000000000003 8.8985276796561098e-06 0.021470000000000003 3.3642478518640028e-06 0.021480000000000003 3.8344407936396934e-07 0.021490000000000002 -3.8229341087247179e-06 0.021500000000000002 1.1188336462300468e-05 0.021510000000000001 2.3955855361423825e-06 0.021520000000000001 7.260485370986429e-08 0.021530000000000001 -5.7107619766920807e-06 0.02154 -5.9796128065607337e-06 0.021550000000000003 -4.9413585920945572e-06 0.021560000000000003 2.3919828413516353e-07 0.021570000000000002 3.769372977201637e-06 0.021580000000000002 4.9827791611603256e-06 0.021590000000000002 7.1606517536007205e-06 0.021600000000000001 -2.1469006489459041e-06 0.021610000000000001 -2.5469382889187827e-06 0.02162 -8.1261862734683617e-06 0.021630000000000003 -6.3093246910988062e-06 0.021640000000000003 3.3098374738259553e-06 0.021650000000000003 2.0724277663076716e-06 0.021660000000000002 4.1914043368652276e-07 0.021670000000000002 5.3961836881445659e-06 0.021680000000000001 -1.4300670394519712e-07 0.021690000000000001 3.5087678208389721e-06 0.021700000000000001 -3.7255331600000734e-06 0.02171 -6.241177107162176e-06 0.021720000000000003 -2.0714213481074759e-06 0.021730000000000003 4.1508804364488522e-06 0.021740000000000002 2.7917886674408978e-06 0.021750000000000002 4.0215063383569806e-07 0.021760000000000002 -4.983048078319686e-06 0.021770000000000001 1.0279230547001645e-05 0.021780000000000001 1.2180483812210289e-06 0.02179 -1.7502011102528215e-06 0.021800000000000003 -4.4643438894623962e-06 0.021810000000000003 -2.6207642504465597e-06 0.021820000000000003 1.4154391850589647e-06 0.021830000000000002 -5.0971445353562842e-06 0.021840000000000002 5.2878571186096438e-06 0.021850000000000001 -5.4963239452208487e-06 0.021860000000000001 -8.2640360376562771e-06 0.021870000000000001 -3.93130617412677e-06 0.02188 3.7207155328313906e-06 0.021890000000000003 -3.3746332682571993e-06 0.021900000000000003 7.4192935759014603e-06 0.021910000000000002 4.3511578238779106e-06 0.021920000000000002 -6.9791704563109399e-07 0.021930000000000002 1.2859765156136267e-07 0.021940000000000001 2.9332825260912469e-06 0.021950000000000001 -4.1163374159922912e-06 0.02196 9.2644022247547472e-06 0.021970000000000003 1.865934942097638e-06 0.021980000000000003 1.6031308804444807e-06 0.021990000000000003 -5.6445789165041679e-06 0.022000000000000002 3.3596840237956989e-06 0.022010000000000002 2.7879175541300835e-06 0.022020000000000001 5.0717835957728026e-06 0.022030000000000001 1.1440500216225458e-06 0.022040000000000001 -4.0474298258701702e-06 0.02205 1.2734398417450258e-05 0.022060000000000003 -8.7217128677814441e-07 0.022070000000000003 -3.5371880092156243e-06 0.022080000000000002 -3.9216971223273507e-06 0.022090000000000002 -1.0077049990317201e-05 0.022100000000000002 -2.5930736056203437e-06 0.022110000000000001 -6.8321982766565154e-07 0.022120000000000001 6.59067318480715e-06 0.02213 2.7346076437288489e-06 0.022140000000000003 -1.804905315026747e-06 0.022150000000000003 5.1840900966423226e-06 0.022160000000000003 2.0857930380960557e-07 0.022170000000000002 1.7202906018997747e-06 0.022180000000000002 -5.1061966652596897e-06 0.022190000000000001 2.5935663243181035e-06 0.022200000000000001 5.9608922703716417e-06 0.022210000000000001 -2.6878287118271234e-06 0.02222 4.8927398832587157e-06 0.022230000000000003 5.2947176094657971e-06 0.022240000000000003 -2.0071752170492718e-07 0.022250000000000002 6.4316969671206906e-06 0.022260000000000002 1.304699433676346e-06 0.022270000000000002 -6.6130127851968371e-06 0.022280000000000001 8.2722104665688028e-06 0.022290000000000001 7.1549824748817374e-06 0.0223 3.7429943994596125e-06 0.022310000000000003 7.6991809505965056e-06 0.022320000000000003 -2.4009798500684618e-06 0.022330000000000003 3.2077842282115092e-06 0.022340000000000002 4.3185764621009511e-06 0.022350000000000002 8.5996199614087718e-06 0.022360000000000001 2.6775037827506177e-07 0.022370000000000001 1.4449834203822644e-05 0.022380000000000001 7.8014278701251695e-06 0.02239 -4.559451386896657e-06 0.022400000000000003 -3.2472553148442407e-08 0.022410000000000003 -7.0279106280782007e-06 0.022420000000000002 1.1302541760457098e-05 0.022430000000000002 1.6491907211918719e-06 0.022440000000000002 3.6557578642378632e-06 0.022450000000000001 3.02263174035577e-06 0.022460000000000001 2.0412255836979337e-06 0.02247 -2.8819532048682225e-06 0.022480000000000003 8.5895459937207172e-07 0.022490000000000003 -1.1260212462490784e-06 0.022500000000000003 1.1070707318428319e-05 0.022510000000000002 1.2997317798575298e-06 0.022520000000000002 -4.588871408401327e-07 0.022530000000000001 -2.7451123711404671e-06 0.022540000000000001 1.6620699205666867e-06 0.022550000000000001 3.4018659572298266e-07 0.02256 -3.3288991084848283e-06 0.022570000000000003 -2.7240080674267858e-06 0.022580000000000003 8.969992571193021e-06 0.022590000000000002 1.4956927932560885e-06 0.022600000000000002 3.8686195027209304e-06 0.022610000000000002 3.680203688347999e-06 0.022620000000000001 4.2531962552173519e-06 0.022630000000000001 1.3074569574654978e-06 0.02264 3.9067835300163526e-06 0.022650000000000003 -6.4105442116043348e-07 0.022660000000000003 -2.8900783669804493e-06 0.022670000000000003 3.6122434289957864e-08 0.022680000000000002 3.9455761127235607e-06 0.022690000000000002 4.0129312111041935e-06 0.022700000000000001 -2.3099518335282665e-06 0.022710000000000001 4.7185679365825424e-07 0.022720000000000001 9.5641889562143976e-06 0.02273 2.8469702971215867e-06 0.022740000000000003 2.2780251955433388e-07 0.022750000000000003 -1.3683992260499538e-06 0.022760000000000002 2.980310593686468e-07 0.022770000000000002 1.3016936616446521e-05 0.022780000000000002 2.376580307410327e-06 0.022790000000000001 -1.1737332853957324e-05 0.022800000000000001 -7.205919413723844e-07 0.02281 -2.1206731619893453e-06 0.022820000000000003 1.9865410405821837e-06 0.022830000000000003 -1.8433534567995395e-06 0.022840000000000003 -4.7315714804749654e-07 0.022850000000000002 4.7535597675984677e-06 0.022860000000000002 -7.9233560331186715e-07 0.022870000000000001 -2.7774749840950256e-06 0.022880000000000001 -3.8031750939251078e-06 0.022890000000000001 -9.4440171056982391e-06 0.0229 1.8338217598086081e-06 0.022910000000000003 4.7811647045917363e-06 0.022920000000000003 2.0367679438541336e-06 0.022930000000000002 9.9805395650741313e-06 0.022940000000000002 -4.8240381428634768e-06 0.022950000000000002 6.4443461913591791e-06 0.022960000000000001 -1.398902204547293e-06 0.022970000000000001 -7.1323996986031511e-06 0.02298 7.1658576685218659e-06 0.022990000000000003 -1.4928070158795741e-06 0.023000000000000003 -3.1749404388772358e-06 0.023010000000000003 3.3849218984219529e-06 0.023020000000000002 2.0044858043474438e-06 0.023030000000000002 3.3397466672002864e-06 0.023040000000000001 2.9803450597028177e-06 0.023050000000000001 3.8211196215872222e-06 0.023060000000000001 -4.0492160168714891e-06 0.02307 6.525749694881373e-07 0.023080000000000003 1.1648466122442347e-06 0.023090000000000003 7.3141673417461168e-06 0.023100000000000002 -4.7829692323161313e-06 0.023110000000000002 -2.6552048205867637e-07 0.023120000000000002 -9.5842726097184431e-07 0.023130000000000001 -5.1805837782303949e-06 0.023140000000000001 1.6889795449618093e-06 0.02315 1.2718979498346374e-06 0.023160000000000004 1.9502271906854484e-06 0.023170000000000003 -1.7589419241316866e-06 0.023180000000000003 5.1221809592636872e-06 0.023190000000000002 3.5833237566085972e-06 0.023200000000000002 -4.4021594319262109e-06 0.023210000000000001 -3.1565788194578504e-06 0.023220000000000001 -1.0636657120421304e-05 0.023230000000000001 1.0302406534991581e-06 0.02324 -8.8701759037626894e-06 0.023250000000000003 2.8681542311244452e-06 0.023260000000000003 7.9288633747750927e-06 0.023270000000000002 2.4666722379656193e-06 0.023280000000000002 -1.7280129433751247e-06 0.023290000000000002 -3.7767347988689868e-06 0.023300000000000001 -2.5527384188655626e-06 0.023310000000000001 -3.0199911530243995e-06 0.02332 -1.4182507706878094e-06 0.023330000000000004 4.010563398311348e-07 0.023340000000000003 -2.9651371077219866e-06 0.023350000000000003 -4.0023466672160601e-06 0.023360000000000002 -6.1310040763277861e-07 0.023370000000000002 -1.2888907523159138e-05 0.023380000000000001 2.2982180226765682e-06 0.023390000000000001 2.5018080896946716e-06 0.023400000000000001 -1.6405279293052446e-06 0.02341 2.5754985076817247e-06 0.023420000000000003 5.8175417283319365e-06 0.023430000000000003 -1.6892632490405577e-06 0.023440000000000003 2.6752226840886219e-07 0.023450000000000002 -1.7662382049467012e-06 0.023460000000000002 3.7213281142317287e-06 0.023470000000000001 3.4749111367086698e-06 0.023480000000000001 1.463510837840664e-06 0.02349 3.2311760866272134e-06 0.023500000000000004 -9.165024700664226e-06 0.023510000000000003 6.6033378327244571e-06 0.023520000000000003 -6.8749956449633451e-06 0.023530000000000002 8.2023114100105465e-07 0.023540000000000002 -6.4989028696773963e-07 0.023550000000000001 8.6485182590271759e-06 0.023560000000000001 8.3313673888710703e-06 0.023570000000000001 3.7542684905888137e-06 0.02358 -1.3575477144772997e-05 0.023590000000000003 8.8986715135729417e-07 0.023600000000000003 3.2908927941937431e-06 0.023610000000000003 -5.7876145493381453e-06 0.023620000000000002 8.5012154844331369e-06 0.023630000000000002 -6.8086753906126356e-06 0.023640000000000001 -4.7973372483225936e-06 0.023650000000000001 1.966491482622223e-07 0.02366 7.847352555571415e-07 0.023670000000000004 -1.2380859962635631e-05 0.023680000000000003 -6.8116769343564551e-06 0.023690000000000003 1.7849361345910642e-08 0.023700000000000002 6.1086901478112784e-07 0.023710000000000002 6.6084981530824139e-07 0.023720000000000001 4.7348001374499989e-06 0.023730000000000001 -1.4338473643139269e-06 0.023740000000000001 -2.5128667945529424e-06 0.02375 -9.0171459983142573e-07 0.023760000000000003 -8.0582526642407342e-06 0.023770000000000003 -1.0518283418385374e-05 0.023780000000000003 9.1496623060176734e-06 0.023790000000000002 -3.4513199095418699e-06 0.023800000000000002 -8.4702330695586125e-06 0.023810000000000001 1.1588442213271121e-06 0.023820000000000001 -3.7121522528358655e-06 0.02383 2.5843954910041219e-07 0.023840000000000004 3.3643171575293943e-06 0.023850000000000003 2.8028491107273641e-07 0.023860000000000003 -1.6898729409963644e-06 0.023870000000000002 -1.5592376342692514e-06 0.023880000000000002 -5.2673814415564952e-06 0.023890000000000002 -1.1210276317271135e-06 0.023900000000000001 -5.241826515794046e-06 0.023910000000000001 -7.8905668468064835e-06 0.02392 4.907084304936194e-06 0.023930000000000003 -7.155477471141682e-06 0.023940000000000003 2.9143016584485074e-06 0.023950000000000003 -2.9362004769699929e-07 0.023960000000000002 -2.91689274913618e-07 0.023970000000000002 -1.7240058544797618e-07 0.023980000000000001 4.9752530378945678e-06 0.023990000000000001 -6.5203695050711667e-07 0.024 -1.4058997126694518e-06)
Bq q_drive 0 V=min(2,max(-2,(v(state)+5.4999999999999995e-05+v(readnoise)+(-5.5015087127685547e-05)+(0.00019997358322143555)*v(state))))
Rq q_drive q 10
Cq q 0 9.9999999999999995e-08
Rport_q q 0 50000
Cport_q q 0 2p
Bd0 d0_drive 0 V=min(2,max(-2,(v(q)+4.76837158203125e-07*((1+0.0016)*v(q)*v(q)+5.4999999999999995e-05)+5.4999999999999995e-05+(-5.4955482482910156e-05)+(0.00020003318786621094)*v(q)+(0)*v(q)+(5.9604644775390625e-08)*v(q)*v(q)+(0)*v(q)*v(q))))
Rd0 d0_drive d0 10
Cd0 d0 0 9.9999999999999995e-08
Rport_d0 d0 0 50000
Cport_d0 d0 0 2p
Bd1 d1_drive 0 V=min(2,max(-2,(v(d0)+0.33333331346511841*(v(q)-v(d0))+6.5565109252929688e-07*((1+0.0016)*v(d0)*v(q)+5.4999999999999995e-05)+5.4999999999999995e-05+(-5.5015087127685547e-05)+(0.00013339519500732422)*v(d0)+(6.6697597503662109e-05)*v(q)+(0)*v(d0)*v(d0)+(1.7881393432617188e-07)*v(d0)*v(q))))
Rd1 d1_drive d1 10
Cd1 d1 0 9.9999999999999995e-08
Rport_d1 d1 0 50000
Cport_d1 d1 0 2p
Bd2 d2_drive 0 V=min(2,max(-2,(v(d1)+1.4901161193847656e-06*((1+0.0016)*v(d1)*v(d1)+5.4999999999999995e-05)+5.4999999999999995e-05+(-5.4955482482910156e-05)+(0.00019985437393188477)*v(d1)+(0)*v(q)+(-1.7881393432617188e-07)*v(d1)*v(d1)+(0)*v(d1)*v(q))))
Rd2 d2_drive d2 10
Cd2 d2 0 9.9999999999999995e-08
Rport_d2 d2 0 50000
Cport_d2 d2 0 2p
Bd3 d3_drive 0 V=min(2,max(-2,(v(d2)+0.1428571343421936*(v(q)-v(d2))+8.3446502685546875e-07*((1+0.0016)*v(d2)*v(q)+5.4999999999999995e-05)+5.4999999999999995e-05+(-5.5015087127685547e-05)+(0.00017148256301879883)*v(d2)+(2.8491020202636719e-05)*v(q)+(0)*v(d2)*v(d2)+(-1.1920928955078125e-07)*v(d2)*v(q))))
Rd3 d3_drive d3 10
Cd3 d3 0 9.9999999999999995e-08
Rport_d3 d3 0 50000
Cport_d3 d3 0 2p
Bd4 d4_drive 0 V=min(2,max(-2,(v(d3)+3.5166740417480469e-06*((1+0.0016)*v(d3)*v(d3)+5.4999999999999995e-05)+5.4999999999999995e-05+(-5.5015087127685547e-05)+(0.00019997358322143555)*v(d3)+(0)*v(q)+(-5.9604644775390625e-08)*v(d3)*v(d3)+(0)*v(d3)*v(q))))
Rd4 d4_drive d4 10
Cd4 d4 0 9.9999999999999995e-08
Rport_d4 d4 0 50000
Cport_d4 d4 0 2p
Bd5 d5_drive 0 V=min(2,max(-2,(v(d4)+0.066666662693023682*(v(q)-v(d4))+9.5367431640625e-07*((1+0.0016)*v(d4)*v(q)+5.4999999999999995e-05)+5.4999999999999995e-05+(-5.5015087127685547e-05)+(0.00018674135208129883)*v(d4)+(1.33514404296875e-05)*v(q)+(0)*v(d4)*v(d4)+(2.384185791015625e-07)*v(d4)*v(q))))
Rd5 d5_drive d5 10
Cd5 d5 0 9.9999999999999995e-08
Rport_d5 d5 0 50000
Cport_d5 d5 0 2p
Bd6 d6_drive 0 V=min(2,max(-2,(v(d5)+7.5101852416992188e-06*((1+0.0016)*v(d5)*v(d5)+5.4999999999999995e-05)+5.4999999999999995e-05+(-5.5015087127685547e-05)+(0.00020021200180053711)*v(d5)+(0)*v(q)+(2.9802322387695312e-07)*v(d5)*v(d5)+(0)*v(d5)*v(q))))
Rd6 d6_drive d6 10
Cd6 d6 0 9.9999999999999995e-08
Rport_d6 d6 0 50000
Cport_d6 d6 0 2p
Bd7 d7_drive 0 V=min(2,max(-2,(v(d6)+1.5020370483398438e-05*((1+0.0016)*v(d6)*v(d6)+5.4999999999999995e-05)+5.4999999999999995e-05+(-5.5015087127685547e-05)+(0.00020003318786621094)*v(d6)+(0)*v(q)+(5.9604644775390625e-08)*v(d6)*v(d6)+(0)*v(d6)*v(q))))
Rd7 d7_drive d7 10
Cd7 d7 0 9.9999999999999995e-08
Rport_d7 d7 0 50000
Cport_d7 d7 0 2p
Bd8 d8_drive 0 V=min(2,max(-2,(v(d7)+0.016393423080444336*(v(q)-v(d7))+1.0132789611816406e-06*((1+0.0016)*v(d7)*v(q)+5.4999999999999995e-05)+5.4999999999999995e-05+(-5.5074691772460938e-05)+(0.00019651651382446289)*v(d7)+(3.0398368835449219e-06)*v(q)+(0)*v(d7)*v(d7)+(-5.9604644775390625e-07)*v(d7)*v(q))))
Rd8 d8_drive d8 10
Cd8 d8 0 9.9999999999999995e-08
Rport_d8 d8 0 50000
Cport_d8 d8 0 2p
Bd9 d9_drive 0 V=min(2,max(-2,(v(d8)+3.0517578125e-05*((1+0.0016)*v(d8)*v(d8)+5.4999999999999995e-05)+5.4999999999999995e-05+(-5.4955482482910156e-05)+(0.00020021200180053711)*v(d8)+(0)*v(q)+(2.384185791015625e-07)*v(d8)*v(d8)+(0)*v(d8)*v(q))))
Rd9 d9_drive d9 10
Cd9 d9 0 9.9999999999999995e-08
Rport_d9 d9 0 50000
Cport_d9 d9 0 2p
Bd10 d10_drive 0 V=min(2,max(-2,(v(d9)+6.0975551605224609e-05*((1+0.0016)*v(d9)*v(d9)+5.4999999999999995e-05)+5.4999999999999995e-05+(-5.4955482482910156e-05)+(0.00019997358322143555)*v(d9)+(0)*v(q)+(-2.384185791015625e-07)*v(d9)*v(d9)+(0)*v(d9)*v(q))))
Rd10 d10_drive d10 10
Cd10 d10 0 9.9999999999999995e-08
Rport_d10 d10 0 50000
Cport_d10 d10 0 2p
Bd11 d11_drive 0 V=min(2,max(-2,(v(d10)+0.00012201070785522461*((1+0.0016)*v(d10)*v(d10)+5.4999999999999995e-05)+5.4999999999999995e-05+(-5.5015087127685547e-05)+(0.00019991397857666016)*v(d10)+(0)*v(q)+(-3.5762786865234375e-07)*v(d10)*v(d10)+(0)*v(d10)*v(q))))
Rd11 d11_drive d11 10
Cd11 d11 0 9.9999999999999995e-08
Rport_d11 d11 0 50000
Cport_d11 d11 0 2p
Bd12 d12_drive 0 V=min(2,max(-2,(v(d11)+0.00024402141571044922*((1+0.0016)*v(d11)*v(d11)+5.4999999999999995e-05)+5.4999999999999995e-05+(-5.5015087127685547e-05)+(0.00019985437393188477)*v(d11)+(0)*v(q)+(-5.9604644775390625e-07)*v(d11)*v(d11)+(0)*v(d11)*v(q))))
Rd12 d12_drive d12 10
Cd12 d12 0 9.9999999999999995e-08
Rport_d12 d12 0 50000
Cport_d12 d12 0 2p
Bd13 d13_drive 0 V=min(2,max(-2,(v(d12)+0.00048798322677612305*((1+0.0016)*v(d12)*v(d12)+5.4999999999999995e-05)+5.4999999999999995e-05+(-5.5015087127685547e-05)+(0.00020009279251098633)*v(d12)+(0)*v(q)+(-7.152557373046875e-07)*v(d12)*v(d12)+(0)*v(d12)*v(q))))
Rd13 d13_drive d13 10
Cd13 d13 0 9.9999999999999995e-08
Rport_d13 d13 0 50000
Cport_d13 d13 0 2p
Bd14 d14_drive 0 V=min(2,max(-2,(v(d13)+0.00051200389862060547*(v(q)-v(d13))+1.0132789611816406e-06*((1+0.0016)*v(d13)*v(q)+5.4999999999999995e-05)+5.4999999999999995e-05+(-5.5015087127685547e-05)+(0.00019985437393188477)*v(d13)+(5.9604644775390625e-08)*v(q)+(0)*v(d13)*v(d13)+(-0)*v(d13)*v(q))))
Rd14 d14_drive d14 10
Cd14 d14 0 9.9999999999999995e-08
Rport_d14 d14 0 50000
Cport_d14 d14 0 2p
Bd15 d15_drive 0 V=min(2,max(-2,(v(d14)+0.00097650289535522461*((1+0.0016)*v(d14)*v(d14)+5.4999999999999995e-05)+5.4999999999999995e-05+(-5.5074691772460938e-05)+(0.00019991397857666016)*v(d14)+(0)*v(q)+(-1.4901161193847656e-06)*v(d14)*v(d14)+(0)*v(d14)*v(q))))
Rd15 d15_drive d15 10
Cd15 d15 0 9.9999999999999995e-08
Rport_d15 d15 0 50000
Cport_d15 d15 0 2p
Bd16 d16_drive 0 V=min(2,max(-2,(v(d15)+0.0019530057907104492*((1+0.0016)*v(d15)*v(d15)+5.4999999999999995e-05)+5.4999999999999995e-05+(-5.5074691772460938e-05)+(0.00020015239715576172)*v(d15)+(0)*v(q)+(-2.5629997253417969e-06)*v(d15)*v(d15)+(0)*v(d15)*v(q))))
Rd16 d16_drive d16 10
Cd16 d16 0 9.9999999999999995e-08
Rport_d16 d16 0 50000
Cport_d16 d16 0 2p
Bd17 d17_drive 0 V=min(2,max(-2,(v(d16)+0.0039060115814208984*((1+0.0016)*v(d16)*v(d16)+5.4999999999999995e-05)+5.4999999999999995e-05+(-5.5193901062011719e-05)+(0.00020015239715576172)*v(d16)+(0)*v(q)+(-5.4240226745605469e-06)*v(d16)*v(d16)+(0)*v(d16)*v(q))))
Rd17 d17_drive d17 10
Cd17 d17 0 9.9999999999999995e-08
Rport_d17 d17 0 50000
Cport_d17 d17 0 2p
Bd18 d18_drive 0 V=min(2,max(-2,(v(d17)+6.4015388488769531e-05*(v(q)-v(d17))+1.0132789611816406e-06*((1+0.0016)*v(d17)*v(q)+5.4999999999999995e-05)+5.4999999999999995e-05+(-5.5015087127685547e-05)+(0.00019997358322143555)*v(d17)+(0)*v(q)+(0)*v(d17)*v(d17)+(0)*v(d17)*v(q))))
Rd18 d18_drive d18 10
Cd18 d18 0 9.9999999999999995e-08
Rport_d18 d18 0 50000
Cport_d18 d18 0 2p
Bd19 d19_drive 0 V=min(2,max(-2,(v(d18)+0.0078125*((1+0.0016)*v(d18)*v(d18)+5.4999999999999995e-05)+5.4999999999999995e-05+(-5.5432319641113281e-05)+(0.00019991397857666016)*v(d18)+(0)*v(q)+(-1.1086463928222656e-05)*v(d18)*v(d18)+(0)*v(d18)*v(q))))
Rd19 d19_drive d19 10
Cd19 d19 0 9.9999999999999995e-08
Rport_d19 d19 0 50000
Cport_d19 d19 0 2p
Bd20 d20_drive 0 V=min(2,max(-2,(v(d19)+0.015625*((1+0.0016)*v(d19)*v(d19)+5.4999999999999995e-05)+5.4999999999999995e-05+(-5.5849552154541016e-05)+(0.00020009279251098633)*v(d19)+(0)*v(q)+(-2.1815299987792969e-05)*v(d19)*v(d19)+(0)*v(d19)*v(q))))
Rd20 d20_drive d20 10
Cd20 d20 0 9.9999999999999995e-08
Rport_d20 d20 0 50000
Cport_d20 d20 0 2p
Bd21 d21_drive 0 V=min(2,max(-2,(v(d20)+0.03125*((1+0.0016)*v(d20)*v(d20)+5.4999999999999995e-05)+5.4999999999999995e-05+(-5.6684017181396484e-05)+(0.00019997358322143555)*v(d20)+(0)*v(q)+(-4.38690185546875e-05)*v(d20)*v(d20)+(0)*v(d20)*v(q))))
Rd21 d21_drive d21 10
Cd21 d21 0 9.9999999999999995e-08
Rport_d21 d21 0 50000
Cport_d21 d21 0 2p
Bd22 d22_drive 0 V=min(2,max(-2,(v(d21)+0.0625*((1+0.0016)*v(d21)*v(d21)+5.4999999999999995e-05)+5.4999999999999995e-05+(-5.8412551879882812e-05)+(0.00020009279251098633)*v(d21)+(0)*v(q)+(-8.7261199951171875e-05)*v(d21)*v(d21)+(0)*v(d21)*v(q))))
Rd22 d22_drive d22 10
Cd22 d22 0 9.9999999999999995e-08
Rport_d22 d22 0 50000
Cport_d22 d22 0 2p
Bd23 d23_drive 0 V=min(2,max(-2,(v(d22)+0.125*((1+0.0016)*v(d22)*v(d22)+5.4999999999999995e-05)+5.4999999999999995e-05+(-6.1869621276855469e-05)+(0.00020009279251098633)*v(d22)+(0)*v(q)+(-0.00017470121383666992)*v(d22)*v(d22)+(0)*v(d22)*v(q))))
Rd23 d23_drive d23 10
Cd23 d23 0 9.9999999999999995e-08
Rport_d23 d23 0 50000
Cport_d23 d23 0 2p
Bd24 d24_drive 0 V=min(2,max(-2,(v(d23)+0.25*((1+0.0016)*v(d23)*v(d23)+5.4999999999999995e-05)+5.4999999999999995e-05+(-6.8783760070800781e-05)+(0.00019997358322143555)*v(d23)+(0)*v(q)+(-0.00034987926483154297)*v(d23)*v(d23)+(0)*v(d23)*v(q))))
Rd24 d24_drive d24 10
Cd24 d24 0 9.9999999999999995e-08
Rport_d24 d24 0 50000
Cport_d24 d24 0 2p
Bpeak stagepeak 0 V=max(max(max(max(max(max(max(max(max(max(max(max(max(max(max(max(max(max(max(max(max(max(max(max(max(abs(v(q_drive)),abs(v(d0_drive))),abs(v(d1_drive))),abs(v(d2_drive))),abs(v(d3_drive))),abs(v(d4_drive))),abs(v(d5_drive))),abs(v(d6_drive))),abs(v(d7_drive))),abs(v(d8_drive))),abs(v(d9_drive))),abs(v(d10_drive))),abs(v(d11_drive))),abs(v(d12_drive))),abs(v(d13_drive))),abs(v(d14_drive))),abs(v(d15_drive))),abs(v(d16_drive))),abs(v(d17_drive))),abs(v(d18_drive))),abs(v(d19_drive))),abs(v(d20_drive))),abs(v(d21_drive))),abs(v(d22_drive))),abs(v(d23_drive))),abs(v(d24_drive)))
Bres residual 0 V=1.2810463905334473*(1+v(d24))
Bden denominator 0 V=1+v(residual)+(v(residual)-1)*1.0132789611816406e-06
Btarget target 0 V=(((v(q)+v(delta))*(1+(0.0016000000000000001))+(5.4999999999999995e-05)+v(targetnoise))-(5.4955482482910156e-05))/(1.001599907875061)
Bcandidate candidate_drive 0 V=min(2,max(-2,v(target)))
Rcandidate candidate_drive candidate 10
Ccandidate candidate 0 100n
Bcorr_first corr_first_drive 0 V=min(2,max(-2,((1+(0.0016000000000000001))*((1+(1.0132789611816406e-06)*(v(q)))+(0.50000050663948059)*v(delta))+(5.4999999999999995e-05)+(-5.5015087127685547e-05)+(-0.001399993896484375)*((1+(1.0132789611816406e-06)*(v(q)))+(0.50000050663948059)*v(delta)))+v(cornoise0)))
Rcorr_first corr_first_drive corr_first 10
Ccorr_first corr_first 0 9.9999999999999995e-08
Rport_corr_first corr_first 0 50000
Cport_corr_first corr_first 0 2p
Bcorr_first_raw corr_first_raw 0 V=((1+(0.0016000000000000001))*((1+(1.0132789611816406e-06)*(v(q)))+(0.50000050663948059)*v(delta))+(5.4999999999999995e-05)+(-5.5015087127685547e-05)+(-0.001399993896484375)*((1+(1.0132789611816406e-06)*(v(q)))+(0.50000050663948059)*v(delta)))+v(cornoise0)
Bdelta delta_drive 0 V=min(2,max(-2,((1+(0.0016000000000000001))*(-((v(residual)-1))*v(corr_first))+(5.4999999999999995e-05)+(-5.5015087127685547e-05)+(-0.001399993896484375)*(-((v(residual)-1))*v(corr_first)))+v(cornoise1)))
Rdelta delta_drive delta 10
Cdelta delta 0 9.9999999999999995e-08
Rport_delta delta 0 50000
Cport_delta delta 0 2p
Bdelta_raw delta_raw 0 V=((1+(0.0016000000000000001))*(-((v(residual)-1))*v(corr_first))+(5.4999999999999995e-05)+(-5.5015087127685547e-05)+(-0.001399993896484375)*(-((v(residual)-1))*v(corr_first)))+v(cornoise1)
Bcorpeak corpeak 0 V=max(abs(v(corr_first_raw)),abs(v(delta_raw)))
Binnerden innerden 0 V=1+(0.50000050663948059)*((v(residual)-1))
Vcornoise0 cornoise0 0 PWL(0 -3.9616589182270107e-06 1.0000000000000001e-05 -2.0405268856044145e-06 2.0000000000000002e-05 -3.327609350228579e-06 3.0000000000000004e-05 -3.3318493611948089e-06 4.0000000000000003e-05 -5.8568640699818499e-06 5.0000000000000002e-05 -2.8913259273010489e-06 6.0000000000000008e-05 -1.8328555557105407e-06 7.0000000000000007e-05 -6.5316090966549227e-06 8.0000000000000007e-05 6.065931106790672e-06 9.0000000000000006e-05 1.0343207963371636e-06 0.0001 -1.2752670393467038e-06 0.00011 2.3887047704072232e-06 0.00012000000000000002 -2.9532139540524694e-06 0.00013000000000000002 7.0396313207172103e-06 0.00014000000000000001 7.2502799152417889e-06 0.00015000000000000001 1.3968308853572557e-06 0.00016000000000000001 -3.9534858085417874e-06 0.00017000000000000001 -5.4900989055271288e-06 0.00018000000000000001 -2.5582955386366607e-06 0.00019000000000000001 3.1631217713370278e-06 0.00020000000000000001 -5.8570364677391119e-06 0.00021000000000000001 -5.1166890334040068e-06 0.00022000000000000001 7.6990345911327655e-07 0.00023000000000000001 3.5137965002415718e-06 0.00024000000000000003 -1.0359754399324887e-06 0.00025000000000000001 2.6851632998812794e-06 0.00026000000000000003 -1.7884529040107416e-06 0.00027 -8.2733858267088898e-06 0.00028000000000000003 4.9778417004872846e-06 0.00029 4.2663741428111187e-06 0.00030000000000000003 8.1434467165117107e-06 0.00031 3.3810663401425408e-06 0.00032000000000000003 -3.7918168545564555e-06 0.00033000000000000005 -1.8297270388814569e-07 0.00034000000000000002 -9.1858221530224561e-06 0.00035000000000000005 -1.3429702233711787e-06 0.00036000000000000002 -9.9988168948562685e-06 0.00037000000000000005 1.8555020378510641e-07 0.00038000000000000002 2.8549020689111036e-06 0.00039000000000000005 8.2145770734499857e-06 0.00040000000000000002 2.5157472453845564e-06 0.00041000000000000005 1.9818986048714064e-06 0.00042000000000000002 -1.9249013649616317e-06 0.00043000000000000004 -4.8654225632694222e-07 0.00044000000000000002 -4.6997946569160725e-06 0.00045000000000000004 -1.07340837095794e-05 0.00046000000000000001 -3.0538386985627283e-06 0.00047000000000000004 4.8238726501398004e-06 0.00048000000000000007 7.5878709643906422e-06 0.00049000000000000009 1.5621577687872104e-07 0.00050000000000000001 4.5378554013708544e-06 0.00051000000000000004 -2.271575745481678e-06 0.00052000000000000006 1.8762829430296745e-06 0.00053000000000000009 8.0793229585994574e-06 0.00054000000000000001 4.3538029805741434e-06 0.00055000000000000003 -1.4085612980655416e-05 0.00056000000000000006 -2.7913326003423825e-06 0.00057000000000000009 2.89116883391358e-06 0.00058 7.5336379082955366e-06 0.00059000000000000003 -1.4765622711855335e-06 0.00060000000000000006 -3.2297602960713781e-06 0.00061000000000000008 7.936228962159272e-06 0.00062 -3.6588651145111498e-06 0.00063000000000000003 -4.614548102187311e-06 0.00064000000000000005 -3.7360751324222634e-06 0.00065000000000000008 -1.4373524510219062e-05 0.0006600000000000001 -8.2900058724259351e-06 0.00067000000000000002 -6.3346046868704792e-07 0.00068000000000000005 1.7727464393671746e-06 0.00069000000000000008 4.8675099820861623e-06 0.0007000000000000001 -8.1301230637228533e-07 0.00071000000000000002 9.8596174960180752e-06 0.00072000000000000005 2.8702737347296737e-06 0.00073000000000000007 4.0934363752055605e-06 0.0007400000000000001 1.8558460338219886e-06 0.00075000000000000002 2.1060582007963004e-06 0.00076000000000000004 -7.3310359501668697e-06 0.00077000000000000007 -1.4879217573727693e-06 0.00078000000000000009 -6.7555241365472623e-06 0.00079000000000000001 4.6581342786756879e-07 0.00080000000000000004 -2.1146439769335013e-07 0.00081000000000000006 1.2082627049929904e-06 0.00082000000000000009 1.9719941965591439e-06 0.00083000000000000012 -3.709113200222033e-06 0.00084000000000000003 -7.6649131153550173e-06 0.00085000000000000006 -6.0008408460218627e-07 0.00086000000000000009 -2.8883801679958527e-06 0.00087000000000000011 3.8848650201256256e-06 0.00088000000000000003 -5.3233685815578053e-07 0.00089000000000000006 -4.9333069308343793e-06 0.00090000000000000008 -8.1853206059651387e-07 0.00091000000000000011 1.4356898503384546e-05 0.00092000000000000003 2.022191651377333e-06 0.00093000000000000005 3.8000068856651156e-06 0.00094000000000000008 2.1751722697339355e-06 0.00095000000000000011 -4.4695714089357901e-06 0.00096000000000000013 -5.059761821286617e-06 0.00097000000000000005 -2.3306275800264218e-06 0.00098000000000000019 -2.1793210091851397e-06 0.00098999999999999999 7.0386837647590932e-06 0.001 3.9509518592785888e-07 0.00101 -9.1165711308917937e-06 0.0010200000000000001 -1.1684902336898033e-06 0.0010300000000000001 -5.1109197363823779e-06 0.0010400000000000001 -6.7599821716055111e-06 0.0010500000000000002 9.5693251980398378e-07 0.0010600000000000002 1.9793207605809602e-06 0.00107 -7.4292616802753531e-07 0.00108 3.1410932226291304e-06 0.00109 -3.1557834917148491e-06 0.0011000000000000001 -6.0507748888272879e-06 0.0011100000000000001 -3.7644886737817458e-06 0.0011200000000000001 8.6745568389973231e-06 0.0011300000000000001 6.7189586942096439e-06 0.0011400000000000002 3.9045577312736814e-06 0.0011500000000000002 3.0223928592253287e-06 0.00116 9.5867675907588456e-06 0.00117 -6.7057316549847587e-07 0.0011800000000000001 2.197475491715575e-06 0.0011900000000000001 4.8936811186169167e-06 0.0012000000000000001 1.7053488275751267e-06 0.0012100000000000001 9.0141531876673685e-06 0.0012200000000000002 4.9754921986819811e-07 0.0012300000000000002 5.7953033023909164e-06 0.00124 -4.7465221810735643e-07 0.00125 -1.3525809392751305e-06 0.0012600000000000001 3.3703379668109374e-07 0.0012700000000000001 3.7739672002133297e-06 0.0012800000000000001 -2.740169337011745e-06 0.0012900000000000001 2.3668379319074493e-06 0.0013000000000000002 -2.231234393006166e-06 0.0013100000000000002 4.7696298690368382e-06 0.0013200000000000002 1.1529440697091776e-05 0.00133 2.6398710173964708e-06 0.00134 2.2320156373690928e-06 0.0013500000000000001 4.3121461124424698e-06 0.0013600000000000001 1.0501714264286697e-05 0.0013700000000000001 1.5819348282718908e-06 0.0013800000000000002 -7.9626017171679785e-06 0.0013900000000000002 -3.5660230373413224e-06 0.0014000000000000002 -3.7916262547257027e-06 0.00141 -8.032974420326781e-06 0.00142 -4.4352972651235951e-06 0.0014300000000000001 -8.9429427706289426e-06 0.0014400000000000001 -4.423078377440287e-07 0.0014500000000000001 3.1104647714075833e-06 0.0014600000000000001 5.2569385316714503e-06 0.0014700000000000002 8.0975009969444246e-06 0.0014800000000000002 -2.6498990879319171e-06 0.0014900000000000002 2.2165677812982102e-06 0.0015 -9.7322592439977926e-06 0.0015100000000000001 -5.8222916515920689e-06 0.0015200000000000001 -1.4037807675224996e-05 0.0015300000000000001 -3.4711925580722089e-06 0.0015400000000000001 2.6632923370537023e-06 0.0015500000000000002 7.1204187857742071e-06 0.0015600000000000002 -4.7547818071226185e-08 0.0015700000000000002 -7.6028737764445538e-07 0.00158 5.9492265732158937e-06 0.0015900000000000001 3.874997606495827e-06 0.0016000000000000001 -1.2906401497893714e-06 0.0016100000000000001 4.3311739220242296e-06 0.0016200000000000001 -7.5453923596554414e-06 0.0016300000000000002 6.7942150967720754e-06 0.0016400000000000002 -4.6768366945455546e-06 0.0016500000000000002 3.5206577851348007e-06 0.0016600000000000002 5.130359117383644e-06 0.00167 1.4510366000913889e-06 0.0016800000000000001 5.5075065657620783e-06 0.0016900000000000001 2.7073065680351218e-06 0.0017000000000000001 -2.7093272643567744e-06 0.0017100000000000001 3.7628653136436098e-06 0.0017200000000000002 1.1427709323799341e-05 0.0017300000000000002 -5.5501888508335859e-08 0.0017400000000000002 -5.3778003989968116e-06 0.00175 -2.3663305581076547e-06 0.0017600000000000001 -2.8222269108115303e-06 0.0017700000000000001 7.5577093941586879e-07 0.0017800000000000001 -7.1358054196485424e-06 0.0017900000000000001 6.7437129694073513e-07 0.0018000000000000002 9.697451610267739e-07 0.0018100000000000002 -3.3248217914910456e-06 0.0018200000000000002 -7.7912615130410115e-06 0.0018300000000000002 5.0561485081992043e-06 0.0018400000000000001 1.684728423986537e-06 0.0018500000000000001 4.9229511364047421e-07 0.0018600000000000001 -1.5557137725336791e-05 0.0018700000000000001 1.1448399266449646e-06 0.0018800000000000002 1.1024809055243261e-05 0.0018900000000000002 -5.2744817539883276e-06 0.0019000000000000002 1.6663886062237952e-06 0.0019100000000000002 -7.1039031105925982e-06 0.0019200000000000003 8.4120903751485474e-06 0.0019300000000000001 -6.0938945874292765e-06 0.0019400000000000001 1.0604528362687975e-06 0.0019500000000000001 1.9597165531454325e-06 0.0019600000000000004 2.7062329902429796e-07 0.00197 -2.2765531503681184e-06 0.00198 -6.1372399365172876e-06 0.00199 1.764494621076563e-06 0.002 1.0463181248541123e-05 0.0020100000000000001 -5.1900907341317485e-07 0.0020200000000000001 -6.7428395823635142e-06 0.0020300000000000001 -7.5046789796816434e-06 0.0020400000000000001 -6.8651135442821938e-06 0.0020500000000000002 1.0267420069270279e-05 0.0020600000000000002 -8.3597716708891338e-06 0.0020700000000000002 3.6277441099727007e-06 0.0020800000000000003 5.1175115269482087e-06 0.0020900000000000003 -9.2805429297089688e-06 0.0021000000000000003 -9.5428111758850291e-06 0.0021100000000000003 5.5017583945167477e-06 0.0021200000000000004 -6.2421598437126887e-06 0.0021300000000000004 -5.0791804481446087e-06 0.00214 -3.3426671193569478e-06 0.00215 -5.5124469631668368e-06 0.00216 8.1739679018201934e-06 0.0021700000000000001 -2.4801520822329036e-06 0.0021800000000000001 8.6780182995349853e-06 0.0021900000000000001 -1.0344855726734924e-05 0.0022000000000000001 -1.2582543006960757e-05 0.0022100000000000002 -7.3126396681248361e-06 0.0022200000000000002 7.1780140799186086e-06 0.0022300000000000002 6.0728245938904424e-07 0.0022400000000000002 7.8337777424489082e-06 0.0022500000000000003 5.0106025497319421e-06 0.0022600000000000003 2.5175085131337862e-06 0.0022700000000000003 -1.0939681623846086e-05 0.0022800000000000003 -9.4159332615062142e-06 0.0022900000000000004 3.4079704616092544e-06 0.0023000000000000004 -6.2634657328779311e-06 0.00231 -6.3756428264242209e-06 0.00232 -7.9276923985506587e-06 0.00233 1.2225713653609798e-05 0.0023400000000000001 4.0608729376759534e-06 0.0023500000000000001 -5.5595249048355679e-06 0.0023600000000000001 2.8442247508551785e-06 0.0023700000000000001 1.6546988532107452e-06 0.0023800000000000002 -4.3859021122794401e-07 0.0023900000000000002 2.3104353309703563e-06 0.0024000000000000002 2.7936927451690338e-06 0.0024100000000000002 -8.487085943311177e-06 0.0024200000000000003 -5.7770634793519061e-06 0.0024300000000000003 8.6476994425747895e-08 0.0024400000000000003 -2.0630851271968845e-06 0.0024500000000000004 1.0858524948411414e-05 0.0024600000000000004 -1.1415772762454273e-06 0.0024700000000000004 4.5240142430440799e-06 0.00248 -3.6273407351998833e-06 0.00249 5.9124673414272353e-08 0.0025000000000000001 -7.7902605739131564e-06 0.0025100000000000001 -2.1014331568688702e-06 0.0025200000000000001 7.2577717445540131e-06 0.0025300000000000001 1.0720400986507213e-06 0.0025400000000000002 -2.2372628005335493e-06 0.0025500000000000002 4.4523952850688448e-06 0.0025600000000000002 -2.2893141507048569e-06 0.0025700000000000002 4.3630455503018493e-06 0.0025800000000000003 -1.3519903009868496e-06 0.0025900000000000003 2.6365924734111235e-06 0.0026000000000000003 -4.6739455267921423e-07 0.0026100000000000003 2.2071463043000625e-06 0.0026200000000000004 8.7062662848352067e-06 0.0026300000000000004 -7.7205555482922538e-06 0.0026400000000000004 1.0301407517974793e-05 0.00265 2.8510206945751271e-06 0.00266 3.360467651278141e-06 0.0026700000000000001 4.3918439810763509e-06 0.0026800000000000001 -3.390555082221794e-06 0.0026900000000000001 -2.3447140504717149e-06 0.0027000000000000001 4.5803530354548527e-06 0.0027100000000000002 2.0876540652251296e-06 0.0027200000000000002 4.4655700957577139e-06 0.0027300000000000002 6.0612482752446811e-06 0.0027400000000000002 1.6833646669676046e-07 0.0027500000000000003 6.2276145714907725e-06 0.0027600000000000003 -4.3421835399497774e-06 0.0027700000000000003 -4.0126691784610421e-06 0.0027800000000000004 -7.6521548116378224e-06 0.0027900000000000004 -2.9718927020582482e-06 0.0028000000000000004 4.6586407466204872e-06 0.0028100000000000004 -1.2176639840779275e-06 0.00282 4.3362159046091787e-06 0.0028300000000000001 2.3528089344067928e-06 0.0028400000000000001 3.4618429881159886e-06 0.0028500000000000001 8.9353204136804913e-07 0.0028600000000000001 2.4961227506692402e-06 0.0028700000000000002 7.4667835933973613e-06 0.0028800000000000002 -4.6477547354656326e-07 0.0028900000000000002 1.529268809760467e-06 0.0029000000000000002 6.1541915679176059e-06 0.0029100000000000003 3.6722050618745207e-06 0.0029200000000000003 -2.2571241708929216e-06 0.0029300000000000003 -2.922538289954373e-06 0.0029400000000000003 -6.6009025831610637e-06 0.0029500000000000004 4.9212975250267612e-06 0.0029600000000000004 1.1052741069000982e-06 0.0029700000000000004 2.5104458269698757e-06 0.0029800000000000004 6.6526483544321252e-06 0.00299 9.0572316929394651e-06 0.0030000000000000001 3.9756764907535145e-06 0.0030100000000000001 -1.111763154465768e-06 0.0030200000000000001 -3.9841497955513219e-06 0.0030300000000000001 1.3513232069934953e-06 0.0030400000000000002 7.4591779700156633e-06 0.0030500000000000002 4.5640495518739843e-07 0.0030600000000000002 6.1886761808864955e-06 0.0030700000000000002 7.222993432723627e-07 0.0030800000000000003 8.3944008205738001e-06 0.0030900000000000003 -5.3530613531005779e-07 0.0031000000000000003 -6.6316634665129291e-07 0.0031100000000000004 7.0549181692284153e-06 0.0031200000000000004 5.1051246065356426e-06 0.0031300000000000004 9.5824830543776453e-06 0.0031400000000000004 1.0761802010142202e-06 0.0031500000000000005 -1.7634796672225011e-06 0.00316 4.5724938774371821e-06 0.0031700000000000001 7.8778230923487824e-06 0.0031800000000000001 3.5125981563695178e-06 0.0031900000000000001 -7.4292587605724321e-06 0.0032000000000000002 1.0957456933133739e-05 0.0032100000000000002 -7.6490910605164126e-06 0.0032200000000000002 -4.5706081851309295e-06 0.0032300000000000002 3.9875586523260985e-06 0.0032400000000000003 2.1847449682174381e-06 0.0032500000000000003 -3.6425427600542312e-06 0.0032600000000000003 -6.180557597890473e-06 0.0032700000000000003 -5.9752622215655133e-06 0.0032800000000000004 -1.1221421835386952e-05 0.0032900000000000004 -3.098615786651399e-06 0.0033000000000000004 -3.5447804813398696e-06 0.0033100000000000004 1.3578974836926972e-06 0.0033200000000000005 5.4499582111823413e-06 0.0033300000000000001 5.2270966357072472e-06 0.0033400000000000001 9.3199241677850221e-06 0.0033500000000000001 -1.6475721084522827e-06 0.0033600000000000001 -2.214148833161027e-06 0.0033700000000000002 -4.7822703023836898e-06 0.0033800000000000002 1.0154070368220182e-05 0.0033900000000000002 -7.3468284757868061e-06 0.0034000000000000002 -1.7057770922598559e-06 0.0034100000000000003 1.2554637056799623e-05 0.0034200000000000003 -2.7161395620403059e-06 0.0034300000000000003 3.0318662909794768e-06 0.0034400000000000003 3.0565584397437659e-06 0.0034500000000000004 1.5475798461446349e-06 0.0034600000000000004 2.6376302677018949e-06 0.0034700000000000004 -4.7773595063841545e-06 0.0034800000000000005 3.061298738661889e-06 0.0034900000000000005 8.2177040273731574e-06 0.0035000000000000001 6.7410720910959081e-06 0.0035100000000000001 -2.4545412193488345e-06 0.0035200000000000001 -4.8616987568251114e-06 0.0035300000000000002 4.7760778951908144e-06 0.0035400000000000002 -6.204637488618486e-06 0.0035500000000000002 -6.7608816841894455e-07 0.0035600000000000002 -4.8641747167203729e-07 0.0035700000000000003 4.4345038987513606e-06 0.0035800000000000003 -5.6943136428962464e-06 0.0035900000000000003 -1.0952541741518903e-05 0.0036000000000000003 3.0475499796097657e-06 0.0036100000000000004 2.0156644401301045e-06 0.0036200000000000004 -3.6463437364606381e-06 0.0036300000000000004 -4.1773583722724356e-06 0.0036400000000000004 2.4135812447344062e-06 0.0036500000000000005 3.6334733775678089e-06 0.0036600000000000005 3.4170526434669745e-06 0.0036700000000000001 -3.6365013676836575e-06 0.0036800000000000001 1.8271158740462991e-06 0.0036900000000000001 -1.8600653822554722e-07 0.0037000000000000002 7.7850083168870664e-06 0.0037100000000000002 -2.9441073979691776e-06 0.0037200000000000002 2.6603046361186664e-06 0.0037300000000000002 8.0308572160138848e-06 0.0037400000000000003 9.6998663523448017e-06 0.0037500000000000003 -6.9352711238834366e-06 0.0037600000000000003 5.9327393707626137e-06 0.0037700000000000003 -1.0937215839019413e-06 0.0037800000000000004 3.2499380693838363e-06 0.0037900000000000004 6.2457779431434769e-06 0.0038000000000000004 4.5182119457450712e-06 0.0038100000000000005 4.7444950439466847e-06 0.0038200000000000005 9.125905138316725e-06 0.0038300000000000005 -2.5450130472774137e-06 0.0038400000000000005 -5.6690104101166683e-06 0.0038500000000000001 4.2793432717783739e-06 0.0038600000000000001 -4.2815931557911504e-06 0.0038700000000000002 -4.0587857936011279e-06 0.0038800000000000002 -3.4025423606465601e-06 0.0038900000000000002 -1.1771245959609454e-06 0.0039000000000000003 -3.0222497462457426e-07 0.0039100000000000003 -1.7036348046533179e-06 0.0039200000000000007 5.2302627308921737e-06 0.0039300000000000003 -3.7157546767061337e-06 0.0039399999999999999 6.3237692015685356e-07 0.0039500000000000004 -3.3125136653503891e-06 0.00396 3.042167933436353e-07 0.0039700000000000004 -3.3042477893137627e-06 0.00398 -4.9837209989589433e-06 0.0039900000000000005 -3.2878760700370159e-06 0.0040000000000000001 -1.2541602999297663e-06 0.0040100000000000005 -3.7952077212487813e-06 0.0040200000000000001 -9.3033795004366397e-08 0.0040300000000000006 6.1855349151833352e-06 0.0040400000000000002 3.547825016505861e-06 0.0040500000000000006 -2.2242596939081564e-06 0.0040600000000000002 -3.2690964815394228e-06 0.0040700000000000007 -1.4379673371275916e-06 0.0040800000000000003 4.507604520930292e-07 0.0040900000000000008 1.5015444937991545e-06 0.0041000000000000003 1.143284891781435e-06 0.0041099999999999999 6.9555052699208003e-06 0.0041200000000000004 -4.421729249489414e-06 0.00413 -2.1252709356410057e-06 0.0041400000000000005 5.1027890268032044e-06 0.00415 -3.3546298995152059e-06 0.0041600000000000005 5.2457666369851657e-06 0.0041700000000000001 2.5798561483599575e-06 0.0041800000000000006 1.3968378768102419e-06 0.0041900000000000001 -7.3411791787853856e-06 0.0042000000000000006 -2.9057066550480527e-06 0.0042100000000000002 3.0892200631554657e-06 0.0042200000000000007 4.0992788949837133e-06 0.0042300000000000003 -5.4886872730343865e-06 0.0042400000000000007 6.7752963028573046e-06 0.0042500000000000003 1.044812116279555e-06 0.0042600000000000008 6.1338882761658957e-06 0.0042700000000000004 3.6618519605133609e-07 0.00428 -3.521281785519841e-06 0.0042900000000000004 -2.6651428092625602e-06 0.0043 -1.0338710587934912e-06 0.0043100000000000005 -5.0297053637026229e-07 0.0043200000000000001 -1.3100294765267936e-05 0.0043300000000000005 5.6504869731447279e-06 0.0043400000000000001 -1.4891470654785902e-05 0.0043500000000000006 4.1469284761993827e-06 0.0043600000000000002 -6.0785693876147771e-06 0.0043700000000000006 3.9958778825398524e-08 0.0043800000000000002 6.205872339667217e-06 0.0043900000000000007 -1.5275543384880495e-06 0.0044000000000000003 -7.1850450884768727e-06 0.0044100000000000007 -4.2301960553640331e-06 0.0044200000000000003 2.3398461148941193e-06 0.0044300000000000008 1.3019046390967131e-07 0.0044400000000000004 -8.025506121291565e-06 0.00445 2.0435370742438129e-06 0.0044600000000000004 -6.1132244640103471e-07 0.00447 -1.4655338068385978e-06 0.0044800000000000005 -2.171796990727744e-06 0.0044900000000000001 7.5711730299900019e-06 0.0045000000000000005 -2.5440098268853171e-07 0.0045100000000000001 8.7452342687309203e-07 0.0045200000000000006 2.4371179974825821e-06 0.0045300000000000002 5.2024702366197077e-06 0.0045400000000000006 8.9280230585860565e-06 0.0045500000000000002 -4.8336947911863915e-06 0.0045600000000000007 -3.5358448863212564e-06 0.0045700000000000003 -6.2965392612385742e-06 0.0045800000000000007 -3.7795297209439185e-06 0.0045900000000000003 -5.0682716869324525e-08 0.0046000000000000008 2.0188139222987798e-06 0.0046100000000000004 -6.1244515945322737e-06 0.00462 -1.7318879826031435e-06 0.0046300000000000004 -3.0251050401665823e-06 0.00464 -1.3930354081424868e-06 0.0046500000000000005 2.7762860037025064e-06 0.0046600000000000001 2.1733805184206654e-06 0.0046700000000000005 -1.3854446631021814e-06 0.0046800000000000001 2.4958145573522624e-06 0.0046900000000000006 1.3462135419947945e-06 0.0047000000000000002 2.7761601051918096e-06 0.0047100000000000006 2.5416489445175151e-06 0.0047200000000000002 -2.5673419576353247e-06 0.0047300000000000007 3.2420859246926079e-06 0.0047400000000000003 4.7975765312622525e-06 0.0047500000000000007 6.2270336065171898e-06 0.0047600000000000003 -3.4854930816707747e-07 0.0047700000000000008 6.8125070129721923e-06 0.0047800000000000004 3.7288140453366674e-06 0.00479 -2.868745668198455e-06 0.0048000000000000004 2.3151688564368619e-06 0.00481 1.6711564243910267e-06 0.0048200000000000005 -5.641513582660565e-06 0.0048300000000000001 4.5227585635861784e-07 0.0048400000000000006 5.0122329999106841e-06 0.0048500000000000001 -3.1321695841975269e-06 0.0048600000000000006 -3.1962071026616743e-06 0.0048700000000000002 9.2949517740286129e-07 0.0048800000000000007 5.0522876646519696e-07 0.0048900000000000002 -1.5606871135088314e-06 0.0049000000000000007 8.0365906070018988e-06 0.0049100000000000003 1.9631991384920564e-06 0.0049200000000000008 4.6291515941566469e-06 0.0049300000000000004 2.943134149850325e-07 0.0049400000000000008 1.4728917330636087e-06 0.0049500000000000004 2.4374126613108114e-06 0.00496 5.3185657852343377e-06 0.0049700000000000005 -4.0543141660299047e-06 0.0049800000000000001 -4.3924988118847682e-06 0.0049900000000000005 -7.6047269231061279e-06 0.0050000000000000001 4.2098572950839045e-06 0.0050100000000000006 -3.9096777125180475e-06 0.0050200000000000002 -4.3543325722512154e-07 0.0050300000000000006 6.4503439833368496e-06 0.0050400000000000002 1.3943621738664131e-06 0.0050500000000000007 5.1801471308029113e-06 0.0050600000000000003 -6.32418853166639e-06 0.0050700000000000007 -2.9267267859874328e-06 0.0050800000000000003 4.9971537263295471e-07 0.0050900000000000008 1.1811322252053326e-05 0.0051000000000000004 -2.6662571737151971e-06 0.0051100000000000008 3.8661422994675981e-06 0.0051200000000000004 1.0674443560109112e-05 0.00513 -4.3706469296713655e-07 0.0051400000000000005 -1.2673253174462079e-05 0.0051500000000000001 1.5383894604307258e-06 0.0051600000000000005 1.0620580092279289e-07 0.0051700000000000001 5.88797562219665e-07 0.0051800000000000006 1.866564268875124e-06 0.0051900000000000002 1.5198246350847195e-06 0.0052000000000000006 1.6192883083598616e-06 0.0052100000000000002 3.4673276685945661e-06 0.0052200000000000007 3.6219236174837855e-08 0.0052300000000000003 -1.9867709058737992e-06 0.0052400000000000007 3.1373851478658551e-06 0.0052500000000000003 -4.1852052829124066e-06 0.0052600000000000008 1.3853363566202091e-05 0.0052700000000000004 -7.0401110214943062e-06 0.0052800000000000008 4.4454598178531209e-06 0.0052900000000000004 4.4150139259005549e-06 0.0053 3.0569211109030333e-06 0.0053100000000000005 -5.1898683544922865e-06 0.0053200000000000001 9.1849008488507265e-06 0.0053300000000000005 2.8166665889776996e-06 0.0053400000000000001 -7.5742896957366777e-07 0.0053500000000000006 -9.2986902355067746e-06 0.0053600000000000002 -1.599538478040429e-06 0.0053700000000000006 5.0645140138299935e-06 0.0053800000000000002 3.0969135500140351e-06 0.0053900000000000007 1.5082630950776432e-06 0.0054000000000000003 7.7338187565317608e-06 0.0054100000000000007 1.061464125132214e-05 0.0054200000000000003 6.7135502357550828e-06 0.0054300000000000008 3.2164074732211503e-06 0.0054400000000000004 -6.8840528039348348e-07 0.0054500000000000009 6.050897468537149e-06 0.0054600000000000004 2.0313493395226865e-06 0.00547 -5.1287352912924846e-06 0.0054800000000000005 9.8393127629404144e-06 0.0054900000000000001 2.6727112991741926e-06 0.0055000000000000005 5.3197272106296219e-06 0.0055100000000000001 9.4434277445546396e-07 0.0055200000000000006 -2.6909583510342019e-06 0.0055300000000000002 1.6228670649392642e-06 0.0055400000000000007 -2.7031142016993682e-06 0.0055500000000000002 3.0894794311408945e-06 0.0055600000000000007 2.2405834521808373e-07 0.0055700000000000003 -1.8390913547952888e-06 0.0055800000000000008 6.0244228573796492e-06 0.0055900000000000004 1.6945763873325729e-05 0.0056000000000000008 -2.7070866827339249e-06 0.0056100000000000004 7.1456769302275656e-06 0.0056200000000000009 -6.0816616636357525e-06 0.0056300000000000005 9.4748847590884374e-07 0.00564 1.5490786679229971e-06 0.0056500000000000005 5.4863535374201944e-06 0.0056600000000000001 2.0269975241700492e-06 0.0056700000000000006 2.7950410178114152e-06 0.0056800000000000002 7.8692022423242741e-06 0.0056900000000000006 2.2937870854715721e-06 0.0057000000000000002 1.2773915582974496e-05 0.0057100000000000007 1.3979324385207191e-06 0.0057200000000000003 -1.250533782291416e-06 0.0057300000000000007 1.1282933257430728e-05 0.0057400000000000003 -3.6941084136966027e-06 0.0057500000000000008 -2.9287447355256121e-06 0.0057600000000000004 4.5441265302098818e-06 0.0057700000000000008 1.5969904073022277e-06 0.0057800000000000004 4.4790418257910197e-06 0.0057900000000000009 9.7059085695215582e-07 0.0058000000000000005 5.6376738961596458e-06 0.0058100000000000001 1.3911769774458061e-05 0.0058200000000000005 1.4459613511234933e-05 0.0058300000000000001 3.6412496215952061e-06 0.0058400000000000006 -1.4965927953824386e-06 0.0058500000000000002 -1.1355738338124793e-05 0.0058600000000000006 -7.5724347749929325e-06 0.0058700000000000002 1.0520084348653854e-05 0.0058800000000000007 8.9194529049565519e-06 0.0058900000000000003 3.8728619700724388e-06 0.0059000000000000007 -6.3972305421022815e-07 0.0059100000000000003 7.5673192695898294e-07 0.0059200000000000008 8.9417929422990269e-06 0.0059300000000000004 5.1537535723734096e-06 0.0059400000000000008 7.9763703074486348e-06 0.0059500000000000004 -1.3138187708876432e-07 0.0059600000000000009 7.8728188593317194e-06 0.0059700000000000005 2.9254741176425268e-06 0.0059800000000000001 -1.0570340811685817e-05 0.0059900000000000005 -8.2800097131869303e-06 0.0060000000000000001 -7.1349425657422571e-07 0.0060100000000000006 2.9716364829438121e-07 0.0060200000000000002 8.2607871069930616e-06 0.0060300000000000006 1.0813190382693823e-06 0.0060400000000000002 -2.1541785803737756e-06 0.0060500000000000007 -9.2607716200438317e-06 0.0060600000000000003 -2.7813279063639143e-06 0.0060700000000000007 2.5577665071440177e-06 0.0060800000000000003 -1.471455860066616e-06 0.0060900000000000008 3.7789845885391248e-07 0.0061000000000000004 2.7650544599517967e-07 0.0061100000000000008 2.2853617768245316e-07 0.0061200000000000004 5.4569283815504924e-06 0.0061300000000000009 -7.7545161234829741e-06 0.0061400000000000005 -1.4260304243607547e-06 0.0061500000000000001 -1.6752644032822632e-06 0.0061600000000000005 5.3588188210483781e-06 0.0061700000000000001 -4.0847244580366885e-08 0.0061800000000000006 4.6882545139849343e-06 0.0061900000000000002 -6.2885635918487075e-06 0.0062000000000000006 -6.947495817131902e-06 0.0062100000000000002 -7.3250212889372787e-06 0.0062200000000000007 6.8765525446965577e-06 0.0062300000000000003 8.1864148791297972e-06 0.0062400000000000008 6.9103083157591358e-06 0.0062500000000000003 -1.0190578663936071e-06 0.0062600000000000008 1.0947690566817656e-05 0.0062700000000000004 -3.8363524441927556e-07 0.0062800000000000009 3.156155655221124e-06 0.0062900000000000005 -3.9403462199370686e-06 0.0063000000000000009 -6.255721485943366e-06 0.0063100000000000005 -3.3211531559425326e-06 0.0063200000000000001 -4.0813173274427179e-06 0.0063300000000000006 -6.5026469741707806e-07 0.0063400000000000001 -4.6746957317113867e-06 0.0063500000000000006 -3.663415114238219e-06 0.0063600000000000002 4.7186813839238929e-06 0.0063700000000000007 -4.2110128350887166e-06 0.0063800000000000003 6.28564593013113e-06 0.0063900000000000007 1.6682052286775076e-06 0.0064000000000000003 8.8572298099915797e-06 0.0064100000000000008 -1.0300560253963888e-05 0.0064200000000000004 -1.8801162494889339e-06 0.0064300000000000008 7.6495890677224478e-06 0.0064400000000000004 9.6493201297578604e-06 0.0064500000000000009 -7.9047850309845769e-06 0.0064600000000000005 -5.6207543915353823e-06 0.0064700000000000009 3.5203450144242534e-06 0.0064800000000000005 -6.7923659191606958e-07 0.0064900000000000001 -1.4575410321168565e-05 0.0065000000000000006 6.6922212587734545e-06 0.0065100000000000002 8.1491957988081372e-06 0.0065200000000000006 -5.5823515865113331e-06 0.0065300000000000002 3.5193802584220815e-06 0.0065400000000000007 3.6841315351614471e-08 0.0065500000000000003 -6.6778008226710937e-06 0.0065600000000000007 1.8904670268930721e-06 0.0065700000000000003 2.1157710033805423e-06 0.0065800000000000008 5.8209993041987769e-07 0.0065900000000000004 -5.4601802666731394e-07 0.0066000000000000008 -5.0986427283557773e-06 0.0066100000000000004 -1.9822757517364717e-06 0.0066200000000000009 2.4526091402830659e-06 0.0066300000000000005 -7.2625422613504135e-06 0.0066400000000000009 -2.5450676051327738e-06 0.0066500000000000005 -4.463788817857044e-07 0.0066600000000000001 1.2276522552575152e-06 0.0066700000000000006 -1.7796285360645063e-06 0.0066800000000000002 -1.8384766935195002e-06 0.0066900000000000006 -3.8800236560221486e-06 0.0067000000000000002 4.0496561140185214e-07 0.0067100000000000007 -9.5819064174793635e-06 0.0067200000000000003 -3.1506418732589e-06 0.0067300000000000007 4.0310848384868268e-06 0.0067400000000000003 1.160605931962363e-06 0.0067500000000000008 -4.630795272597873e-07 0.0067600000000000004 -3.3058239573939111e-06 0.0067700000000000008 -7.8968932943842135e-06 0.0067800000000000004 5.0916063351819455e-06 0.0067900000000000009 -4.0962774998334362e-06 0.0068000000000000005 -6.5272803341043191e-06 0.0068100000000000009 -3.3672450957102989e-06 0.0068200000000000005 7.1561021046878028e-07 0.0068300000000000001 4.7228628258086996e-07 0.0068400000000000006 -1.156446480825878e-06 0.0068500000000000002 1.3998898575957184e-06 0.0068600000000000006 2.7092885393844836e-06 0.0068700000000000002 3.4760464582233965e-06 0.0068800000000000007 1.159677442866318e-06 0.0068900000000000003 -4.1184170790137415e-06 0.0069000000000000008 1.2641684454908541e-07 0.0069100000000000003 2.1025571346081042e-06 0.0069200000000000008 -4.8161841215800495e-07 0.0069300000000000004 1.0216845880286924e-05 0.0069400000000000009 -2.5957802987878504e-06 0.0069500000000000004 4.5719415538915281e-06 0.0069600000000000009 3.5702458231574614e-07 0.0069700000000000005 -7.9337510062591985e-06 0.006980000000000001 -5.9603043036261034e-06 0.0069900000000000006 -7.639779446171322e-06 0.0070000000000000001 9.3887710689382426e-06 0.0070100000000000006 -4.9000899316002356e-07 0.0070200000000000002 2.7917882338151253e-06 0.0070300000000000007 -8.3188620939111497e-06 0.0070400000000000003 -2.6155785822781758e-06 0.0070500000000000007 4.6242446440147751e-06 0.0070600000000000003 3.7490517705833473e-06 0.0070700000000000008 5.7202680683580831e-07 0.0070800000000000004 -2.5183737252331126e-07 0.0070900000000000008 -7.1312407443443731e-06 0.0071000000000000004 5.6685194602158645e-06 0.0071100000000000009 -5.7098790780652326e-07 0.0071200000000000005 5.1476086022191547e-07 0.0071300000000000009 -6.4649250650677443e-06 0.0071400000000000005 3.4157830614817392e-07 0.007150000000000001 -3.5921164850150698e-06 0.0071600000000000006 1.7171660462016526e-06 0.0071700000000000002 1.4200332365623113e-06 0.0071800000000000006 -2.5447042008464823e-06 0.0071900000000000002 4.6262329990484653e-06 0.0072000000000000007 5.3886734733447284e-07 0.0072100000000000003 3.9794761806271535e-06 0.0072200000000000007 6.8464422778054023e-07 0.0072300000000000003 -1.4751005498464056e-06 0.0072400000000000008 -4.9442567087603318e-06 0.0072500000000000004 -2.858065666716709e-07 0.0072600000000000008 5.090947995680896e-08 0.0072700000000000004 -2.8289783179991356e-07 0.0072800000000000009 6.3094054281497205e-08 0.0072900000000000005 -2.5066448929328218e-06 0.0073000000000000009 4.8512741863993546e-06 0.0073100000000000005 -1.5146254158704892e-06 0.007320000000000001 -1.2442605459740314e-07 0.0073300000000000006 -2.2846733149174454e-06 0.0073400000000000002 1.9755610136439307e-06 0.0073500000000000006 1.3265259863945599e-05 0.0073600000000000002 -2.5511063344699537e-06 0.0073700000000000007 2.2138080270979546e-06 0.0073800000000000003 4.307754539758485e-06 0.0073900000000000007 2.1283614700719017e-06 0.0074000000000000003 -3.3265128533888802e-06 0.0074100000000000008 5.27274149769726e-07 0.0074200000000000004 -6.7719826373326317e-06 0.0074300000000000008 -2.8587113199501604e-06 0.0074400000000000004 2.7214660664082077e-06 0.0074500000000000009 -2.2504493713144306e-06 0.0074600000000000005 -2.038587526304406e-06 0.0074700000000000009 3.1420688017480404e-06 0.0074800000000000005 4.584404582919276e-06 0.007490000000000001 4.6228179431690401e-07 0.0075000000000000006 -2.877940581651255e-06 0.0075100000000000002 -3.2345594243058569e-06 0.0075200000000000006 8.0643320638697698e-06 0.0075300000000000002 1.9643137951784196e-06 0.0075400000000000007 -6.8636708789648413e-06 0.0075500000000000003 -2.8819244069130642e-07 0.0075600000000000007 1.4719523615314676e-06 0.0075700000000000003 5.6005077174969539e-07 0.0075800000000000008 -7.4427569275156434e-06 0.0075900000000000004 2.27937083169834e-06 0.0076000000000000009 1.519907054352035e-06 0.0076100000000000004 3.4886147190222614e-06 0.0076200000000000009 -2.2465356801241008e-06 0.0076300000000000005 5.8176899130809606e-06 0.007640000000000001 9.8811837137047501e-06 0.0076500000000000005 -2.7449298316175371e-06 0.007660000000000001 -1.0533839345682267e-06 0.0076700000000000006 6.3730776808262175e-06 0.0076800000000000011 -1.1121338271672559e-06 0.0076900000000000007 -2.3831927579016736e-06 0.0077000000000000002 -1.4947298737789907e-06 0.0077100000000000007 -5.0501065265062732e-07 0.0077200000000000003 3.51943772580207e-06 0.0077300000000000008 -5.6576379462535687e-06 0.0077400000000000004 -1.0532462896528915e-06 0.0077500000000000008 -1.5953643853921031e-06 0.0077600000000000004 1.097995334226476e-06 0.0077700000000000009 5.8222364403271529e-07 0.0077800000000000005 -4.7627538779596373e-06 0.0077900000000000009 -5.5466736874869852e-06 0.0078000000000000005 4.3726247057741521e-06 0.007810000000000001 6.2124100664844244e-07 0.0078200000000000006 1.8046100133764113e-06 0.0078300000000000002 -4.8378159515561267e-06 0.0078400000000000015 -1.7642794228451461e-06 0.0078500000000000011 -4.0102993752165333e-06 0.0078600000000000007 -1.0236334021172758e-05 0.0078700000000000003 2.2595391595157304e-06 0.0078799999999999999 3.450447116524165e-06 0.0078900000000000012 -8.4754167174260904e-06 0.0079000000000000008 -4.2670292411328889e-06 0.0079100000000000004 1.9651141230802891e-06 0.00792 -2.4434024837039915e-06 0.0079300000000000013 6.5924078342590426e-07 0.0079400000000000009 -9.2714152444447371e-07 0.0079500000000000005 -6.5687980198312818e-06 0.0079600000000000001 -5.9368293719460278e-06 0.0079700000000000014 4.1147237135713166e-06 0.007980000000000001 1.7838289624640073e-07 0.0079900000000000006 2.9956970634801381e-06 0.0080000000000000002 -3.3799960982322126e-07 0.0080100000000000015 -1.1156570257096985e-05 0.0080200000000000011 3.1046537236312963e-06 0.0080300000000000007 -5.6853240098001028e-06 0.0080400000000000003 -1.6854852850923678e-06 0.0080499999999999999 5.6630114370223521e-06 0.0080600000000000012 -1.4917762781690631e-06 0.0080700000000000008 6.0332173160931082e-06 0.0080800000000000004 1.1792157699255645e-06 0.00809 4.5273741779754134e-06 0.0081000000000000013 4.3268846080215918e-06 0.0081100000000000009 2.316894629940512e-06 0.0081200000000000005 -3.9832211378286838e-06 0.0081300000000000001 -4.8507565630110001e-07 0.0081400000000000014 -1.509099452106791e-06 0.008150000000000001 -4.4311899068076828e-06 0.0081600000000000006 -4.2061674515216832e-07 0.0081700000000000002 4.800539852734786e-06 0.0081800000000000015 -4.0523267553788091e-06 0.0081900000000000011 1.3603143765871094e-06 0.0082000000000000007 -1.6124497603341078e-06 0.0082100000000000003 -7.4449060426970998e-06 0.0082199999999999999 2.5480419587876127e-07 0.0082300000000000012 -6.1453405366534117e-07 0.0082400000000000008 4.4758644660225949e-06 0.0082500000000000004 4.2195830550997841e-06 0.00826 1.9496195725593016e-06 0.0082700000000000013 -4.688497654932531e-06 0.0082800000000000009 -2.3430119203325243e-06 0.0082900000000000005 -5.8219465458237157e-07 0.0083000000000000001 4.4993950220822355e-06 0.0083100000000000014 7.5191713461341412e-07 0.008320000000000001 3.3078210831063296e-06 0.0083300000000000006 -2.5687159932023409e-06 0.0083400000000000002 -1.0742170142238019e-06 0.0083500000000000015 6.4391247179661534e-06 0.0083600000000000011 2.9186113692294747e-06 0.0083700000000000007 5.2364386416282243e-06 0.0083800000000000003 1.0958248141794712e-05 0.0083899999999999999 3.3734924379422585e-06 0.0084000000000000012 -3.1426209110591237e-06 0.0084100000000000008 -2.6348234018697011e-06 0.0084200000000000004 1.0171926009132798e-06 0.00843 -4.2518573362202584e-06 0.0084400000000000013 4.3857362013783862e-07 0.0084500000000000009 1.2212268584678935e-06 0.0084600000000000005 7.1860858845171193e-06 0.0084700000000000001 -5.2343972148146793e-06 0.0084800000000000014 -1.8034722843448112e-06 0.008490000000000001 -8.3263885592860745e-06 0.0085000000000000006 -1.7300735965030447e-06 0.0085100000000000002 3.0508653505831328e-06 0.0085200000000000015 4.3083285409537672e-06 0.0085300000000000011 5.9236636584784193e-06 0.0085400000000000007 -1.2822369057929545e-06 0.0085500000000000003 -9.0484626309094286e-07 0.0085599999999999999 -5.5654092187042565e-06 0.0085700000000000012 1.112021745089719e-05 0.0085800000000000008 3.9409256927841774e-06 0.0085900000000000004 8.0388235641098628e-08 0.0086 -3.7145523071880162e-06 0.0086100000000000013 -2.1644582857425671e-06 0.0086200000000000009 -7.8464365605720204e-06 0.0086300000000000005 -2.9602434578049316e-06 0.0086400000000000001 2.9014202552908704e-06 0.0086500000000000014 -4.3523185623257892e-06 0.008660000000000001 -7.8938257430125196e-06 0.0086700000000000006 -8.2260682815070078e-07 0.0086800000000000002 -4.7311508442556732e-06 0.0086900000000000015 -4.4763447370941306e-06 0.0087000000000000011 8.271807176986506e-07 0.0087100000000000007 6.8376997537418035e-06 0.0087200000000000003 9.0683150355880243e-07 0.0087299999999999999 -1.1066721192183453e-06 0.0087400000000000012 1.4620111299378177e-05 0.0087500000000000008 1.9672633928415619e-06 0.0087600000000000004 -5.2888630046249735e-06 0.00877 -8.2615099295144373e-06 0.0087800000000000013 6.5794994604827245e-06 0.0087900000000000009 -2.4917842910644405e-06 0.0088000000000000005 4.7985931433809974e-06 0.0088100000000000001 5.4510945997644612e-07 0.0088200000000000014 8.4140447799767028e-06 0.008830000000000001 4.3754067544849825e-06 0.0088400000000000006 -5.4499093539103712e-06 0.0088500000000000002 -1.0059769068325913e-06 0.0088600000000000016 2.1471773186307228e-06 0.0088700000000000011 4.6103928942913224e-06 0.0088800000000000007 7.313617013145516e-07 0.0088900000000000003 1.3473204005890373e-05 0.0088999999999999999 1.9948587498571477e-06 0.0089100000000000013 -5.7377122030772973e-06 0.0089200000000000008 9.3251124750543123e-07 0.0089300000000000004 -1.7735268882331406e-07 0.00894 -4.120590989044223e-06 0.0089500000000000014 -4.525954527059722e-06 0.0089600000000000009 5.6914050833994228e-06 0.0089700000000000005 7.108663036505466e-07 0.0089800000000000001 5.6134946850946142e-07 0.0089900000000000015 1.5779637371580716e-07 0.0090000000000000011 -1.2752049014046331e-06 0.0090100000000000006 6.2413948566614659e-06 0.0090200000000000002 -5.6690517021987105e-06 0.0090300000000000016 -7.539051989965348e-06 0.0090400000000000012 3.4531940096951417e-06 0.0090500000000000008 6.0915351759621136e-06 0.0090600000000000003 -6.9787722944314139e-06 0.0090699999999999999 -1.2974445182873089e-06 0.0090800000000000013 6.130550009014926e-06 0.0090900000000000009 1.181285143811566e-07 0.0091000000000000004 6.954601488655948e-06 0.00911 -2.4361461672277624e-07 0.0091200000000000014 -7.3663017193672185e-06 0.009130000000000001 7.8111624967709113e-07 0.0091400000000000006 1.2415930074586085e-06 0.0091500000000000001 -6.5381800665045028e-06 0.0091600000000000015 3.7809164279998534e-07 0.0091700000000000011 4.8803967046349425e-06 0.0091800000000000007 -4.7585195462440579e-06 0.0091900000000000003 4.869134698023301e-06 0.0092000000000000016 -3.1082539021265906e-06 0.0092100000000000012 -7.1398251602503453e-06 0.0092200000000000008 1.0335573440656163e-06 0.0092300000000000004 2.5907533016784532e-06 0.0092399999999999999 -4.7775838887035166e-06 0.0092500000000000013 -3.3656615098959151e-06 0.0092600000000000009 -6.9885747198340164e-07 0.0092700000000000005 3.7718083667502371e-06 0.0092800000000000001 1.7061035865819256e-06 0.0092900000000000014 8.2118762463883296e-06 0.009300000000000001 -7.8102609522389025e-06 0.0093100000000000006 1.696749568630946e-06 0.0093200000000000002 5.127797891785216e-06 0.0093300000000000015 -9.289096965949637e-06 0.0093400000000000011 -3.4509224412561837e-06 0.0093500000000000007 -6.2029815444948313e-06 0.0093600000000000003 -2.6775258628214231e-06 0.0093700000000000016 -4.2997200531564321e-06 0.0093800000000000012 1.5229627361805838e-06 0.0093900000000000008 1.2552911830221579e-07 0.0094000000000000004 1.8084566065567351e-08 0.00941 3.6101648549071883e-06 0.0094200000000000013 -5.6690079535508888e-06 0.0094300000000000009 -4.3220034102132801e-06 0.0094400000000000005 7.5736070692171512e-06 0.0094500000000000001 -1.6335907148534802e-06 0.0094600000000000014 5.4190865083916182e-06 0.009470000000000001 3.9189649618443042e-06 0.0094800000000000006 8.1842025335708491e-07 0.0094900000000000002 -7.0502280081243002e-06 0.0095000000000000015 4.4319920246575711e-06 0.0095100000000000011 -3.4079840033350404e-06 0.0095200000000000007 -4.3435331381851442e-06 0.0095300000000000003 -1.6626822487622305e-06 0.0095400000000000016 -1.9108113269092325e-06 0.0095500000000000012 -1.1441255499575346e-06 0.0095600000000000008 1.8386494386303969e-06 0.0095700000000000004 4.1047556658817093e-06 0.00958 5.9120083263914209e-06 0.0095900000000000013 -1.5408507058731271e-05 0.0096000000000000009 -1.7218299310253994e-06 0.0096100000000000005 5.1678671670186933e-06 0.0096200000000000001 -2.2646157679414263e-07 0.0096300000000000014 -1.5599238611135652e-06 0.009640000000000001 4.708290761647284e-07 0.0096500000000000006 1.5245306531894032e-06 0.0096600000000000002 3.8249176494803525e-07 0.0096700000000000015 2.2904528304447593e-06 0.0096800000000000011 3.9547480429696842e-06 0.0096900000000000007 4.8473499101130054e-06 0.0097000000000000003 6.5227963050729347e-06 0.0097100000000000016 -4.295491326704323e-06 0.0097200000000000012 -8.5326375530364794e-07 0.0097300000000000008 -5.4584501783794795e-07 0.0097400000000000004 1.3172824648322128e-06 0.00975 5.9005230214668787e-06 0.0097600000000000013 1.5255751382672877e-06 0.0097700000000000009 -3.2027378342898819e-06 0.0097800000000000005 -5.0674535533291559e-06 0.0097900000000000001 3.4706775258018155e-06 0.0098000000000000014 4.503052455447724e-06 0.009810000000000001 -6.1261081302414393e-06 0.0098200000000000006 -8.9264203426393425e-07 0.0098300000000000002 -8.629666491343957e-08 0.0098400000000000015 -3.1369844330236788e-06 0.0098500000000000011 -6.5412792306486839e-06 0.0098600000000000007 -3.8657136505241284e-07 0.0098700000000000003 -4.8777648314951536e-06 0.0098800000000000016 4.8073661664425394e-06 0.0098900000000000012 4.1169586949409732e-06 0.0099000000000000008 -5.3863662224010848e-06 0.0099100000000000004 1.7594533803719679e-06 0.00992 6.4115020922468566e-06 0.0099300000000000013 -3.1193242099060715e-06 0.0099400000000000009 4.8889439807444138e-07 0.0099500000000000005 6.3468584221533395e-06 0.0099600000000000001 -5.7941949086375296e-06 0.0099700000000000014 -3.6859587579221993e-07 0.009980000000000001 4.6557091934101037e-06 0.0099900000000000006 6.8815382399047002e-06 0.01 2.502895191341543e-06 0.010010000000000002 1.2498931247018963e-06 0.010020000000000001 2.684310179116545e-06 0.010030000000000001 1.1051708030121624e-06 0.01004 4.8447109865216715e-07 0.010050000000000002 -8.7713575487250443e-07 0.010060000000000001 -8.0639973502452534e-06 0.010070000000000001 7.5675893858397198e-06 0.01008 -7.3313212616481078e-07 0.01009 4.8569602285146381e-06 0.010100000000000001 -4.6385569141508974e-06 0.010110000000000001 4.5992369717814814e-06 0.010120000000000001 6.0060545417533131e-06 0.01013 2.0847715709704494e-07 0.010140000000000001 -1.406790164839442e-06 0.010150000000000001 5.0728387326407502e-06 0.010160000000000001 -1.5264937616672943e-06 0.01017 -4.7009275772101029e-06 0.010180000000000002 -3.3207660606250224e-06 0.010190000000000001 -2.2963741414525251e-06 0.010200000000000001 -4.9712195991081564e-06 0.01021 -1.0252810908281379e-06 0.010220000000000002 1.5585594584005135e-06 0.010230000000000001 -1.3996139595792143e-06 0.010240000000000001 2.0190431753889699e-06 0.01025 -1.3066783256022209e-06 0.01026 -1.0614801681645602e-05 0.010270000000000001 2.1841817452468512e-06 0.010280000000000001 2.4085083694486404e-06 0.010290000000000001 2.4049311847062108e-06 0.0103 -4.8025880872444674e-08 0.010310000000000001 -3.7814479247541115e-07 0.010320000000000001 -5.1312546838063052e-07 0.010330000000000001 4.1972757740073175e-06 0.01034 5.8427718385232604e-06 0.010350000000000002 6.7217826483062654e-06 0.010360000000000001 2.0827302069465073e-06 0.010370000000000001 -3.2620458950815379e-06 0.01038 -5.2078591483661132e-06 0.010390000000000002 -2.3787241014893121e-06 0.010400000000000001 -8.5460486852024022e-06 0.010410000000000001 2.9017499732150595e-08 0.01042 -2.9662125261507291e-06 0.01043 -1.2050979593225583e-07 0.010440000000000001 1.3438932795347033e-06 0.010450000000000001 -5.9791673655443038e-06 0.010460000000000001 4.5961643071112355e-07 0.01047 3.6232576092319345e-06 0.010480000000000001 9.9572581204112989e-06 0.010490000000000001 -2.4048310215796585e-06 0.010500000000000001 4.99816711060617e-06 0.01051 -2.7761103382872306e-06 0.010520000000000002 -8.3887425697933188e-06 0.010530000000000001 -3.1607744534112466e-06 0.010540000000000001 -3.8418404094025615e-06 0.01055 2.3002139490578605e-06 0.010560000000000002 7.0547298680579272e-07 0.010570000000000001 1.7008519450819508e-06 0.010580000000000001 -5.1479661786459613e-06 0.01059 -3.5032347871472561e-06 0.0106 3.5822290213536853e-06 0.010610000000000001 -1.5731537215057813e-06 0.010620000000000001 -1.1286218212386681e-07 0.010630000000000001 -2.675979825671716e-06 0.01064 -5.2112341908854814e-06 0.010650000000000001 -4.8628494557686504e-07 0.010660000000000001 8.0541214007950203e-06 0.010670000000000001 -1.5499536700524046e-07 0.01068 2.2177840883571629e-06 0.010690000000000002 -4.8319500559549638e-06 0.010700000000000001 3.5094362607768e-06 0.010710000000000001 1.5434892438758316e-06 0.01072 8.8198266729310129e-06 0.010730000000000002 -3.5385215838240433e-06 0.010740000000000001 -1.1421850195892545e-05 0.010750000000000001 2.4213274356908571e-06 0.01076 -2.7238775117902061e-06 0.01077 -1.0658507991680111e-06 0.010780000000000001 5.8772868792605431e-06 0.010790000000000001 6.350611672347922e-06 0.010800000000000001 -3.4404669418283277e-06 0.01081 9.7914160833646121e-07 0.010820000000000001 3.1512479692316951e-06 0.010830000000000001 4.9747061382388506e-06 0.010840000000000001 4.4732955451274499e-06 0.01085 -2.1760534993273403e-06 0.010860000000000002 4.0263712807648133e-06 0.010870000000000001 -6.504357746792693e-07 0.010880000000000001 2.7333843239516351e-06 0.01089 -5.2060628473844263e-06 0.010900000000000002 -6.5201773898832299e-06 0.010910000000000001 -2.4229961704018907e-06 0.010920000000000001 7.1237846899487236e-07 0.01093 5.2143638057882043e-06 0.01094 5.9986174402435281e-06 0.010950000000000001 -3.4708548979258551e-06 0.010960000000000001 1.0168891139621968e-06 0.010970000000000001 -7.8349990085404529e-06 0.01098 -1.007080694237357e-06 0.010990000000000002 -2.7395899531892033e-06 0.011000000000000001 -1.5577285917788538e-07 0.011010000000000001 7.0807599493351764e-06 0.01102 -6.4388980840867647e-06 0.011030000000000002 -7.4342345022083251e-06 0.011040000000000001 -1.7886040028477375e-08 0.011050000000000001 4.8413412227634905e-06 0.01106 2.881304302116434e-06 0.011070000000000002 7.6267229804507656e-06 0.011080000000000001 -2.198701123662072e-06 0.011090000000000001 9.2908661342454384e-06 0.0111 -1.694140767165596e-06 0.01111 1.1822725850745529e-06 0.011120000000000001 7.2503357349514527e-06 0.011130000000000001 -4.5507066071276515e-06 0.011140000000000001 -4.7691828365626789e-06 0.01115 1.4404638673530903e-07 0.011160000000000002 4.637537069967474e-06 0.011170000000000001 -8.6271308670509679e-06 0.011180000000000001 1.0236573232665765e-05 0.01119 1.2460174338856923e-05 0.011200000000000002 -1.1673737680183004e-05 0.011210000000000001 1.6891313556710663e-06 0.011220000000000001 3.3395130787278975e-06 0.01123 -1.3007869282575284e-06 0.011240000000000002 1.1484992961745158e-05 0.011250000000000001 6.2476365093653028e-06 0.011260000000000001 -3.653344591644023e-07 0.011270000000000001 -8.1911057262842202e-06 0.01128 -1.2489165040520258e-06 0.011290000000000001 -8.3214112277890093e-06 0.011300000000000001 6.0202135898868516e-06 0.011310000000000001 8.2230240380475931e-07 0.01132 3.6248340793192739e-06 0.011330000000000002 9.0081767359339207e-07 0.011340000000000001 7.5544526378997509e-06 0.011350000000000001 7.6678092492972252e-06 0.01136 -4.4425131751003373e-06 0.011370000000000002 -5.9102940930555065e-06 0.011380000000000001 3.8018737067475486e-06 0.011390000000000001 -1.0810973817626501e-06 0.0114 -1.036548115106669e-05 0.011410000000000002 4.3333162040626283e-06 0.011420000000000001 -2.7785284319928048e-06 0.011430000000000001 -5.0019704761238447e-07 0.011440000000000001 -1.0931726994332638e-06 0.01145 2.112911479375255e-06 0.011460000000000001 -2.3873050638634356e-06 0.011470000000000001 2.9551164431906217e-06 0.011480000000000001 -9.8384126829341407e-06 0.01149 8.3443345992089153e-06 0.011500000000000002 -7.7455692469147097e-06 0.011510000000000001 4.0655393985946665e-06 0.011520000000000001 -9.4103160902528809e-06 0.01153 -3.5066654104959856e-06 0.011540000000000002 -5.7724669237492148e-06 0.011550000000000001 8.7680613929972598e-06 0.011560000000000001 -2.3456079380035895e-06 0.01157 -4.0767550244160744e-06 0.011580000000000002 -1.9244737903506148e-06 0.011590000000000001 9.8576829819655223e-06 0.011600000000000001 2.1537058034309137e-07 0.011610000000000001 -2.2717341930562405e-06 0.01162 -1.4067915585167175e-06 0.011630000000000001 1.3976065432135e-06 0.011640000000000001 2.236167008882675e-07 0.011650000000000001 -7.3597771943694219e-06 0.01166 1.4652098114192927e-05 0.011670000000000002 -6.9615325065683305e-06 0.011680000000000001 4.3882873471173265e-07 0.011690000000000001 -1.0294272021218008e-05 0.0117 -6.6470908409488837e-06 0.011710000000000002 -2.7826280024234169e-06 0.011720000000000001 7.997452344633955e-06 0.011730000000000001 8.7433222498890889e-07 0.01174 -3.0052722435454639e-06 0.011750000000000002 2.8038052025693681e-07 0.011760000000000001 -1.7538787376289931e-07 0.011770000000000001 1.5177443345049807e-07 0.011780000000000001 -2.0423227933498177e-06 0.01179 -3.3554296930792473e-06 0.011800000000000001 3.0753781700485096e-06 0.011810000000000001 1.3052606804185589e-06 0.011820000000000001 -6.1657597622632678e-06 0.01183 6.6292487203629686e-06 0.011840000000000002 3.2661666029221994e-06 0.011850000000000001 -2.1430397807140623e-06 0.011860000000000001 -2.2456013623188933e-06 0.01187 -7.0293863332182544e-06 0.011880000000000002 8.193700050318957e-06 0.011890000000000001 -2.8549845785527495e-06 0.011900000000000001 1.6950136624637549e-06 0.01191 -4.5188512397511411e-06 0.011920000000000002 -5.2758788402707152e-06 0.011930000000000001 7.9810536178557848e-06 0.011940000000000001 -7.3788236872426263e-06 0.011950000000000001 2.0358879106226364e-06 0.01196 -6.8256641357683662e-06 0.011970000000000001 3.0430492406832513e-06 0.011980000000000001 -1.877810618822718e-06 0.011990000000000001 7.3234271379578102e-06 0.012 1.3239876507766524e-06 0.012010000000000002 -3.6637040336661468e-06 0.012020000000000001 -4.7274396221805093e-06 0.012030000000000001 1.3041377987536194e-06 0.01204 5.0841653061439165e-06 0.012050000000000002 -4.581412412892383e-07 0.012060000000000001 2.5823659448607991e-06 0.012070000000000001 -5.5851144545499465e-06 0.01208 8.1877100832241366e-06 0.012090000000000002 -5.5625148142816743e-06 0.012100000000000001 2.2882616703609227e-06 0.012110000000000001 1.0677905799093256e-05 0.012120000000000001 1.9562917356729558e-06 0.01213 3.9573933583530233e-07 0.012140000000000001 -1.9312802929046423e-06 0.012150000000000001 -4.6127071726241168e-06 0.012160000000000001 -1.1377219526590309e-05 0.01217 5.8046740150098128e-06 0.012180000000000002 3.7885389715920178e-07 0.012190000000000001 7.4464185843999226e-07 0.012200000000000001 4.7299231946628061e-06 0.01221 6.7534492263794352e-06 0.012220000000000002 -3.5422248053682673e-06 0.012230000000000001 -1.319260216348846e-06 0.012240000000000001 2.8900516660915188e-06 0.01225 -3.7002401300422774e-06 0.012260000000000002 -1.45880191286496e-06 0.012270000000000001 6.9500240337385846e-06 0.012280000000000001 3.1698540822496078e-07 0.012290000000000001 -5.4148096716906066e-06 0.0123 -7.3064200503665549e-06 0.012310000000000001 -6.2604013759438961e-06 0.012320000000000001 -6.6851666864172726e-06 0.012330000000000001 -9.3416431255698458e-06 0.01234 -8.3507125693760002e-06 0.012350000000000002 6.4791572718901184e-06 0.012360000000000001 -5.5990959901181793e-07 0.012370000000000001 1.3933747914690655e-06 0.01238 -1.7267558734446475e-06 0.012390000000000002 -5.1897000847556867e-06 0.012400000000000001 -2.833962158982003e-06 0.012410000000000001 1.8657554618744153e-06 0.01242 4.7114204721962661e-06 0.012430000000000002 8.335288465129537e-07 0.012440000000000001 3.5210284449733548e-07 0.012450000000000001 2.744715182341685e-06 0.012460000000000001 5.6342569798986277e-06 0.01247 -5.5691485233043687e-07 0.012480000000000002 2.2826079372592351e-06 0.012490000000000001 -3.4905269764983373e-06 0.012500000000000001 5.9294710073945972e-06 0.01251 -8.2277776766713618e-06 0.012520000000000002 -2.635745814322922e-06 0.012530000000000001 -5.6561097066504334e-06 0.012540000000000001 -2.0717038180895665e-07 0.01255 4.7618137772462031e-07 0.012560000000000002 5.3038271502030672e-06 0.012570000000000001 -1.7918838753308068e-06 0.012580000000000001 -2.9642984508589586e-06 0.01259 3.2590406306246447e-06 0.012600000000000002 -6.9266323319640035e-06 0.012610000000000001 -2.2788203616388244e-06 0.012620000000000001 -4.2734839558572788e-06 0.012630000000000001 -5.18575186016262e-06 0.01264 3.283638543075197e-06 0.012650000000000002 1.7376681808913924e-06 0.012660000000000001 1.1209499070301567e-06 0.012670000000000001 -1.4262635437378261e-06 0.01268 -1.0702055852121429e-05 0.012690000000000002 -9.8734021206064176e-08 0.012700000000000001 -1.2798789753644786e-06 0.012710000000000001 4.3149734785432344e-07 0.01272 1.7495723701609327e-06 0.012730000000000002 1.9089943939556761e-06 0.012740000000000001 -6.6098001537907906e-06 0.012750000000000001 -8.5336459568955774e-06 0.012760000000000001 -1.3022772874931939e-06 0.012770000000000002 -9.840865929985558e-07 0.012780000000000001 3.3072302377086411e-06 0.012790000000000001 -1.2019818893751197e-06 0.012800000000000001 -2.8437205779107573e-06 0.01281 6.3197840432208747e-06 0.012820000000000002 2.6376347422275118e-06 0.012830000000000001 2.528250911138976e-06 0.012840000000000001 -1.6384250670796383e-06 0.01285 -8.6476395264489919e-07 0.012860000000000002 3.8622041364362023e-06 0.012870000000000001 -8.2216510519637918e-07 0.012880000000000001 2.7071210195358301e-06 0.01289 -1.3318793911904363e-06 0.012900000000000002 3.0457221643518319e-06 0.012910000000000001 -2.824549095708765e-07 0.012920000000000001 4.0724856599655991e-06 0.012930000000000001 -6.0268079606995202e-06 0.012940000000000002 4.1521621918439425e-06 0.012950000000000001 -4.9070239626380116e-06 0.012960000000000001 6.2917828485581175e-07 0.012970000000000001 -5.6991149120697549e-06 0.01298 -8.2067644592623709e-06 0.012990000000000002 3.832572873687959e-06 0.013000000000000001 1.2915245151591107e-05 0.013010000000000001 -3.8682275990975464e-06 0.01302 6.1888875670010332e-07 0.013030000000000002 -8.8201524189446635e-06 0.013040000000000001 -1.6193951653501836e-06 0.013050000000000001 4.4547771823439129e-06 0.01306 8.0337558335546654e-06 0.013070000000000002 -1.3813891514801355e-06 0.013080000000000001 6.3958279112990852e-07 0.013090000000000001 5.1439620732981007e-07 0.013100000000000001 4.7162353059871215e-06 0.013110000000000002 5.3550189861586751e-06 0.013120000000000001 8.9417609143092204e-06 0.013130000000000001 2.8040654839433819e-06 0.013140000000000001 2.087238105554844e-06 0.01315 -3.0191178533941074e-06 0.013160000000000002 4.6070711993679559e-06 0.013170000000000001 -8.635560810183546e-06 0.013180000000000001 -7.7412278928513126e-06 0.01319 -1.6678030493442163e-06 0.013200000000000002 -3.457427228158262e-06 0.013210000000000001 -9.103178794753542e-07 0.013220000000000001 -1.6422368420858317e-06 0.01323 9.365728434517626e-07 0.013240000000000002 1.1117665995998905e-06 0.013250000000000001 6.1693362495427534e-06 0.013260000000000001 -1.9272972900949598e-07 0.013270000000000001 -1.7930901079914705e-06 0.013280000000000002 -3.0175173519648373e-06 0.013290000000000001 -2.6182142898265659e-06 0.013300000000000001 -1.1100724414184196e-05 0.013310000000000001 9.3627476132685518e-06 0.01332 -1.0172168570129567e-06 0.013330000000000002 -1.0254119592839672e-06 0.013340000000000001 1.2724297784871048e-06 0.013350000000000001 4.5251433681298026e-06 0.01336 1.6143253856356055e-06 0.013370000000000002 5.753767978939368e-07 0.013380000000000001 -3.2092428396689188e-07 0.013390000000000001 -7.9936046762237967e-06 0.0134 -2.2850091501170469e-06 0.013410000000000002 -2.2549599963318177e-06 0.013420000000000001 3.7053918311427541e-06 0.013430000000000001 -1.0334812677513681e-05 0.013440000000000001 -3.902012466852206e-06 0.013450000000000002 2.5605868739014529e-06 0.013460000000000001 -7.6448949058200908e-07 0.013470000000000001 -3.6925414639207498e-06 0.013480000000000001 4.1393615458880957e-06 0.01349 -3.9455281660383101e-06 0.013500000000000002 -4.0089258652996396e-06 0.013510000000000001 -3.7993990773407291e-06 0.013520000000000001 -1.1431150783443412e-05 0.01353 -2.8362599880094198e-06 0.013540000000000002 -2.9242010990781521e-06 0.013550000000000001 3.3845737163239843e-06 0.013560000000000001 -3.1716768016845124e-06 0.01357 -1.154685787796717e-06 0.013580000000000002 5.2318611983989939e-06 0.013590000000000001 1.1243360206930841e-05 0.013600000000000001 6.6867899600187771e-06 0.013610000000000001 -1.5470673784573218e-06 0.013620000000000002 -5.2722437887640289e-06 0.013630000000000001 3.7431195077302694e-06 0.013640000000000001 7.4992017060952473e-06 0.013650000000000001 -1.8692005674929934e-06 0.01366 5.0597162994404723e-06 0.013670000000000002 -3.5271092905680009e-07 0.013680000000000001 3.4981523675013507e-06 0.013690000000000001 7.2794362940953554e-06 0.0137 -3.1531548005105971e-06 0.013710000000000002 3.1361737613074701e-06 0.013720000000000001 6.7389934381922853e-06 0.013730000000000001 1.2253753958116604e-06 0.01374 -5.5571549456959497e-06 0.013750000000000002 4.2049611073740125e-06 0.013760000000000001 6.0668589726726968e-06 0.013770000000000001 5.7419606175370909e-06 0.013780000000000001 -7.5438637386799009e-06 0.013790000000000002 -5.1409563434149048e-06 0.013800000000000002 -1.7578017804900687e-06 0.013810000000000001 -1.4472905709750257e-05 0.013820000000000001 -8.8708178489172073e-06 0.01383 -8.3353795017571008e-06 0.013840000000000002 8.4139065065020166e-06 0.013850000000000001 3.91978885672224e-06 0.013860000000000001 -3.8735470557255866e-06 0.01387 -2.3860778925503243e-06 0.013880000000000002 9.1479182199122285e-06 0.013890000000000001 1.0346103853942077e-05 0.013900000000000001 -3.8303029280198409e-06 0.01391 4.1382494962796124e-08 0.013920000000000002 1.5471488138635602e-06 0.013930000000000001 8.1807177199404656e-06 0.013940000000000001 1.0839939003251781e-05 0.013950000000000001 -2.4919807866751035e-06 0.013960000000000002 3.0267401460078938e-06 0.013970000000000002 1.5958070867846458e-05 0.013980000000000001 9.8101498782803181e-06 0.013990000000000001 -4.540579729633672e-06 0.014 1.1824725184915618e-06 0.014010000000000002 -2.8323220892586465e-06 0.014020000000000001 5.6447912883590881e-06 0.014030000000000001 6.2102143222495049e-06 0.01404 -3.9480177285387901e-06 0.014050000000000002 -6.1550905524640396e-06 0.014060000000000001 3.3605794262033071e-06 0.014070000000000001 3.2734384142402474e-06 0.014080000000000001 -2.3734361382872484e-06 0.014090000000000002 2.3901221905603873e-06 0.014100000000000001 -4.861983658616558e-07 0.014110000000000001 4.0556549075919744e-06 0.014120000000000001 -5.1424405843675165e-06 0.014130000000000002 5.4031295388624339e-06 0.014140000000000002 -4.062968949459378e-06 0.014150000000000001 3.4148846312975309e-06 0.014160000000000001 6.3119036140004687e-06 0.01417 3.6703211845198826e-06 0.014180000000000002 7.0967503893097641e-06 0.014190000000000001 -3.8854243543974373e-06 0.014200000000000001 1.1457645079654961e-05 0.01421 -4.4357967241577081e-07 0.014220000000000002 -3.2671475996604511e-06 0.014230000000000001 2.9523639265370093e-06 0.014240000000000001 -2.5678467539420691e-06 0.014250000000000001 1.6361699135260353e-07 0.014260000000000002 7.8982676927452945e-06 0.014270000000000001 -7.9989969187951082e-06 0.014280000000000001 1.1054306686832986e-06 0.014290000000000001 -1.453121309517527e-06 0.014300000000000002 2.8727273324994356e-07 0.014310000000000002 -1.4695337411625317e-07 0.014320000000000001 1.1235338029103979e-06 0.014330000000000001 -9.4260447108441639e-06 0.01434 2.7070948788583156e-06 0.014350000000000002 2.9586856660549742e-06 0.014360000000000001 7.6306155190048428e-06 0.014370000000000001 -2.2112862387259087e-07 0.01438 -3.6704424274966272e-06 0.014390000000000002 -4.8546145123104547e-06 0.014400000000000001 -8.9911099270449795e-06 0.014410000000000001 2.8385969453973182e-06 0.014420000000000001 -1.5752815082152343e-06 0.014430000000000002 -3.8456174497120593e-06 0.014440000000000001 1.6541887131247913e-07 0.014450000000000001 3.6564146136404084e-06 0.014460000000000001 5.1264987211495291e-06 0.014470000000000002 4.1252426951188813e-07 0.014480000000000002 -3.6788101135008074e-06 0.014490000000000001 -5.0026690603299765e-06 0.014500000000000001 1.3025465992404068e-06 0.01451 7.0118201694446907e-06 0.014520000000000002 -4.7874174875650283e-06 0.014530000000000001 4.4980268453101952e-06 0.014540000000000001 2.681545057082534e-06 0.01455 4.3246590564568574e-06 0.014560000000000002 3.1608627763847344e-07 0.014570000000000001 3.5814546480450178e-08 0.014580000000000001 2.5967504255311254e-08 0.014590000000000001 -4.450822588902051e-07 0.014600000000000002 -6.2474199616270794e-07 0.014610000000000001 -7.1989770708941789e-06 0.014620000000000001 2.9728983687611946e-06 0.014630000000000001 -1.9063378897051157e-06 0.014640000000000002 6.3720599106838173e-06 0.014650000000000002 1.0880346950112975e-06 0.014660000000000001 1.7776996445392016e-06 0.014670000000000001 -2.8603279258623964e-06 0.01468 -2.06572554623971e-06 0.014690000000000002 -2.379290596206848e-06 0.014700000000000001 -3.3077284281559996e-06 0.014710000000000001 -5.3922785112434573e-06 0.01472 -5.8813511362854348e-06 0.014730000000000002 5.7129453519421944e-06 0.014740000000000001 2.4955327755747015e-08 0.014750000000000001 -3.2785415402214021e-06 0.014760000000000001 6.6837982603050465e-06 0.014770000000000002 1.2940030702329491e-05 0.014780000000000001 -2.3865952575982651e-06 0.014790000000000001 6.2140225016578815e-06 0.014800000000000001 5.1684924342663411e-06 0.014810000000000002 -2.9698961218595563e-06 0.014820000000000002 -4.7018906551016528e-06 0.014830000000000001 7.2475484163937424e-06 0.014840000000000001 -5.4659893565470365e-06 0.01485 1.7599271560036542e-06 0.014860000000000002 3.912489628577537e-06 0.014870000000000001 2.2329246351567836e-06 0.014880000000000001 -7.5810997771505778e-07 0.01489 -1.1772956358781293e-06 0.014900000000000002 3.7874211243941383e-06 0.014910000000000001 2.7160476886378871e-06 0.014920000000000001 5.0503617535535907e-06 0.014930000000000001 -1.9230038198312642e-06 0.014940000000000002 1.2105447171314851e-06 0.014950000000000001 1.0590236732468354e-05 0.014960000000000001 1.3933533510868854e-06 0.014970000000000001 -3.0411127878318015e-06 0.014980000000000002 -9.2035600135875384e-06 0.014990000000000002 2.7318733442437451e-07 0.015000000000000001 3.2128043096994479e-07 0.015010000000000001 1.7777099145868222e-08 0.01502 -6.7564199676746087e-06 0.015030000000000002 -3.9109192203784839e-06 0.015040000000000001 2.0407916868487297e-06 0.015050000000000001 -4.6678618590917867e-06 0.01506 -1.860603465444571e-06 0.015070000000000002 2.6733657236443604e-06 0.015080000000000001 -4.9264670498416471e-06 0.015090000000000001 4.8911040006984369e-06 0.015100000000000001 -4.7463754592550366e-06 0.015110000000000002 -2.9672061833004212e-06 0.015120000000000001 -8.1042686804471796e-06 0.015130000000000001 -3.5272167818371803e-06 0.015140000000000001 1.6048302417846441e-05 0.015150000000000002 -4.1108316912025243e-06 0.015160000000000002 -1.8252891106654278e-06 0.015170000000000001 3.7180769502464015e-06 0.015180000000000001 1.2240435451404779e-05 0.01519 2.3917161921705403e-07 0.015200000000000002 4.1591514961652487e-06 0.015210000000000001 1.2466724838644359e-05 0.015220000000000001 2.3016543010945357e-06 0.01523 7.130660635961721e-07 0.015240000000000002 -6.140467325284276e-06 0.015250000000000001 -4.0069085188905581e-06 0.015260000000000001 -5.941731557261174e-07 0.015270000000000001 -3.2254268241749279e-06 0.015280000000000002 -2.2532862487566039e-06 0.015290000000000002 6.6494543975695434e-06 0.015300000000000001 -5.8842588550822258e-06 0.015310000000000001 -5.2015511555240528e-07 0.015320000000000002 -2.2376187472527774e-07 0.015330000000000002 1.3967436002030171e-07 0.015340000000000001 1.9251422260364267e-06 0.015350000000000001 2.3523236945470068e-06 0.015360000000000002 -1.2135711115885156e-06 0.015370000000000002 -5.6797521604253515e-06 0.015380000000000001 3.9658184372262214e-06 0.015390000000000001 2.5533301286972574e-06 0.0154 -6.522886194176583e-06 0.015410000000000002 -1.4154458870295514e-06 0.015420000000000001 5.2008583949612038e-06 0.015430000000000001 2.9571551824816552e-06 0.015440000000000001 8.339681019873389e-06 0.015450000000000002 5.5506359650399865e-06 0.015460000000000002 2.7904425128598829e-06 0.015470000000000001 -1.9067565513526192e-07 0.015480000000000001 2.9900670715845354e-06 0.015490000000000002 5.5847561982965374e-07 0.015500000000000002 7.9767670678583685e-06 0.015510000000000001 -7.5278660899021152e-07 0.015520000000000001 3.2518156223776997e-06 0.015530000000000002 3.3508868499957681e-06 0.015540000000000002 9.5213574330427676e-06 0.015550000000000001 3.0459716473181404e-06 0.015560000000000001 4.0245286193400311e-06 0.015570000000000001 -2.5969567755648112e-06 0.015580000000000002 -9.5982640009547848e-06 0.015590000000000001 3.6669651351381897e-06 0.015600000000000001 5.196181180975689e-06 0.015610000000000001 -5.9448345672928387e-06 0.015620000000000002 4.412162093873559e-06 0.015630000000000002 -4.5533535179515332e-06 0.015640000000000001 -5.2095701102369366e-06 0.015650000000000001 4.4924426074011705e-06 0.01566 -1.4723376947027271e-06 0.01567 1.8465016339453653e-06 0.015680000000000003 -2.5161192816806214e-06 0.015690000000000003 1.7771788897875086e-06 0.015700000000000002 -3.302300557842344e-07 0.015710000000000002 -3.2177402544851185e-06 0.015720000000000001 5.1988438299698804e-06 0.015730000000000001 1.9483437652790875e-06 0.015740000000000001 -1.0628396338970768e-06 0.01575 2.6228901260616753e-06 0.01576 5.4985868583053288e-06 0.015770000000000003 3.9636767218748033e-06 0.015780000000000002 5.0191874564457062e-07 0.015790000000000002 2.5171620421594518e-06 0.015800000000000002 7.8444371524639571e-06 0.015810000000000001 -2.1390132441024177e-06 0.015820000000000001 -2.3311739932226577e-06 0.01583 -1.515192671611776e-06 0.01584 7.6696208634014269e-06 0.015850000000000003 -1.0800549968242696e-06 0.015860000000000003 2.1242572958305839e-06 0.015870000000000002 1.5988886378943294e-06 0.015880000000000002 1.0513374623001344e-06 0.015890000000000001 4.5317713959705736e-06 0.015900000000000001 7.5070392978951546e-06 0.015910000000000001 3.5822958991467777e-06 0.01592 -2.2290308106210411e-06 0.01593 -5.2829356844408655e-06 0.015940000000000003 -4.8949643556418199e-06 0.015950000000000002 5.1847307542125706e-06 0.015960000000000002 2.9266560774432702e-06 0.015970000000000002 2.6873476858612586e-06 0.015980000000000001 2.1118908006813628e-06 0.015990000000000001 -2.7901631720443737e-06 0.016 3.6670291589528573e-06 0.01601 1.668605091718779e-05 0.016020000000000003 -6.6619070356898278e-06 0.016030000000000003 -8.6699206364515199e-06 0.016040000000000002 -3.7767379829335244e-06 0.016050000000000002 -5.4164425986963207e-07 0.016060000000000001 -4.4885708339777903e-06 0.016070000000000001 2.9369044732302932e-06 0.016080000000000001 1.9146535949409525e-06 0.01609 -4.5412747180269848e-06 0.0161 9.1361906163276626e-06 0.016110000000000003 -1.9610252662093869e-06 0.016120000000000002 6.5265631761418583e-06 0.016130000000000002 7.8652844804380705e-06 0.016140000000000002 7.1427571704577229e-06 0.016150000000000001 1.6947928077965925e-06 0.016160000000000001 -2.906535280261893e-06 0.01617 3.884856282251974e-06 0.01618 1.8259853086383827e-06 0.016190000000000003 -4.4627031173376738e-06 0.016200000000000003 -9.7404475560677051e-07 0.016210000000000002 -4.2529134313773335e-07 0.016220000000000002 -4.3653890377268099e-06 0.016230000000000001 2.2349054208302967e-07 0.016240000000000001 -1.8143724427751539e-06 0.016250000000000001 3.1723582773945544e-06 0.01626 2.2822341754113898e-06 0.01627 3.172535651909945e-06 0.016280000000000003 7.5262501301936643e-06 0.016290000000000002 3.850897503210252e-06 0.016300000000000002 6.5706231901512249e-06 0.016310000000000002 6.9314294521574388e-06 0.016320000000000001 -9.3822369690738743e-06 0.016330000000000001 3.1753544712287783e-06 0.01634 -9.8123158707569868e-06 0.01635 -1.5473675174043202e-06 0.016360000000000003 -7.6941757000114306e-07 0.016370000000000003 2.3440506223371902e-06 0.016380000000000002 -3.4146093254904462e-06 0.016390000000000002 -2.7597723763629214e-06 0.016400000000000001 3.5018988315144747e-06 0.016410000000000001 -4.4241296520856335e-06 0.016420000000000001 -4.8160016876835827e-06 0.01643 -6.3344428321553833e-06 0.01644 3.9520960614891309e-06 0.016450000000000003 3.2664550124670229e-06 0.016460000000000002 6.0463610908567047e-06 0.016470000000000002 -7.9042283772185197e-06 0.016480000000000002 5.1215393066982788e-06 0.016490000000000001 3.7104097116355503e-06 0.016500000000000001 3.8490489230681987e-07 0.01651 -1.1363839899869506e-06 0.01652 -1.1049253319494672e-05 0.016530000000000003 -4.9193818448234317e-06 0.016540000000000003 1.5371005865449879e-06 0.016550000000000002 -2.56040339110002e-06 0.016560000000000002 -3.3302611165108605e-06 0.016570000000000001 -1.948090895248191e-06 0.016580000000000001 -3.3225921525034155e-06 0.016590000000000001 2.1422478996117198e-06 0.0166 4.147563091089832e-06 0.01661 -1.1928248794823456e-05 0.016620000000000003 -4.5392611162952586e-07 0.016630000000000002 -1.4599720503628075e-06 0.016640000000000002 -5.7784136437709339e-06 0.016650000000000002 1.760977199555896e-06 0.016660000000000001 -8.6987595909750181e-07 0.016670000000000001 -1.4225950247336665e-05 0.01668 8.2362682676970857e-06 0.01669 -2.5494837151193218e-06 0.016700000000000003 -5.8179839990089333e-07 0.016710000000000003 -1.6997342707860686e-06 0.016720000000000002 -5.0957999467988131e-06 0.016730000000000002 1.3571217387940713e-06 0.016740000000000001 -2.3026462521743391e-06 0.016750000000000001 -1.0026958904074674e-05 0.016760000000000001 -7.3879388593135246e-06 0.01677 -1.1497849505491263e-08 0.01678 -4.6627227884083989e-08 0.016790000000000003 9.5504990187683782e-06 0.016800000000000002 -3.2548663291379669e-06 0.016810000000000002 -6.8837505627158208e-06 0.016820000000000002 1.0712536394670361e-06 0.016830000000000001 -2.7312611776909245e-06 0.016840000000000001 -2.2242151173570941e-08 0.01685 -3.6189675793762739e-06 0.01686 4.5104824713526731e-06 0.016870000000000003 -1.8555125552583588e-06 0.016880000000000003 7.8297693275092542e-06 0.016890000000000002 2.0079880122260216e-06 0.016900000000000002 3.0976935940095904e-07 0.016910000000000001 1.1816838404559609e-05 0.016920000000000001 1.8598759646094025e-06 0.016930000000000001 1.0441212167426937e-05 0.01694 3.2627976425862671e-06 0.01695 -1.2494362612977147e-05 0.016960000000000003 -2.8523004826665222e-06 0.016970000000000002 1.0033248710905869e-05 0.016980000000000002 -4.3529993248495403e-06 0.016990000000000002 2.9648150763844518e-06 0.017000000000000001 1.1689693465648153e-05 0.017010000000000001 1.4172613141775815e-06 0.01702 -8.0669166996371226e-07 0.01703 -4.953714599348276e-06 0.017040000000000003 7.0336924883082666e-06 0.017050000000000003 -7.4711964811633725e-07 0.017060000000000002 3.59527593156199e-06 0.017070000000000002 5.2144515907240342e-06 0.017080000000000001 1.648465159831235e-06 0.017090000000000001 1.3111894157362037e-07 0.017100000000000001 5.5292744157105139e-06 0.01711 -3.951804304237882e-06 0.01712 4.2940900516010941e-06 0.017130000000000003 -8.5730527522425553e-06 0.017140000000000002 5.5529994905139437e-06 0.017150000000000002 -2.152024637297479e-06 0.017160000000000002 1.7039899862353185e-06 0.017170000000000001 -5.2473871104981511e-06 0.017180000000000001 5.2484123810365414e-06 0.01719 4.7588895403206317e-06 0.0172 7.5153927084718027e-06 0.017210000000000003 -3.609972404112425e-06 0.017220000000000003 -2.429081339425235e-06 0.017230000000000002 -1.6976260276904893e-06 0.017240000000000002 -3.7632392579757644e-06 0.017250000000000001 3.6674646981460671e-06 0.017260000000000001 4.6697811867468177e-07 0.017270000000000001 3.1699368751768232e-06 0.01728 -7.0840684931237884e-06 0.01729 1.931936541010413e-06 0.017300000000000003 -5.3299170482270478e-07 0.017310000000000002 -5.4997085756776699e-06 0.017320000000000002 3.9889049018060356e-06 0.017330000000000002 -6.0424519631064014e-06 0.017340000000000001 8.324287839215379e-06 0.017350000000000001 4.5967668262702216e-06 0.01736 -9.4315509009429177e-06 0.01737 -8.6331975176058174e-06 0.017380000000000003 -2.6403126182442234e-07 0.017390000000000003 -1.5325004507435936e-07 0.017400000000000002 -2.3514424972159967e-06 0.017410000000000002 5.5167439273642054e-06 0.017420000000000001 6.3050421236219469e-06 0.017430000000000001 -1.5205885182670796e-06 0.017440000000000001 -1.9986742525911534e-06 0.01745 -2.120651867621779e-07 0.01746 6.2760317232699866e-07 0.017470000000000003 1.1155807101628697e-06 0.017480000000000002 -6.0763258353469913e-07 0.017490000000000002 5.0928980631954184e-06 0.017500000000000002 5.8836362718882412e-07 0.017510000000000001 3.0800694192977872e-06 0.017520000000000001 -7.2600181174437459e-07 0.01753 2.6209290939046853e-07 0.01754 2.221491479511845e-06 0.017550000000000003 -9.3547806290618615e-07 0.017560000000000003 -2.9352142289930498e-06 0.017570000000000002 -2.5089432061799467e-06 0.017580000000000002 1.2896942634062143e-06 0.017590000000000001 -4.3482564454692925e-06 0.017600000000000001 3.7538692228220545e-06 0.017610000000000001 -8.1867087360991995e-07 0.01762 8.38781907589894e-07 0.01763 -3.3692453689400063e-07 0.017640000000000003 7.1256015534658055e-06 0.017650000000000002 4.2009023988341821e-06 0.017660000000000002 6.2454180651648717e-06 0.017670000000000002 -1.3211669259529198e-06 0.017680000000000001 7.3625849620140175e-06 0.017690000000000001 6.4196069982370791e-06 0.0177 5.7375627066385527e-06 0.01771 4.4780129503557563e-06 0.017720000000000003 8.0108128383722464e-07 0.017730000000000003 8.4907375101280771e-06 0.017740000000000002 -4.7448516823989872e-06 0.017750000000000002 -3.4506434885336821e-07 0.017760000000000001 1.7473111688606711e-06 0.017770000000000001 2.7042667618355748e-06 0.017780000000000001 2.4381588390973115e-06 0.01779 7.2690389902449814e-07 0.0178 -6.2480067813310843e-07 0.017810000000000003 -1.1312805106832732e-05 0.017820000000000003 -5.3147141312024356e-06 0.017830000000000002 -3.8315485617364197e-06 0.017840000000000002 4.4939509522887227e-06 0.017850000000000001 3.4119968504872171e-06 0.017860000000000001 -3.1646507144742773e-07 0.01787 -4.3473988384012e-06 0.01788 2.9156706248930324e-06 0.017890000000000003 -3.0079030698748928e-06 0.017900000000000003 -3.6774398502577391e-06 0.017910000000000002 4.8613771369555455e-07 0.017920000000000002 1.5902161172324709e-06 0.017930000000000001 1.1632195965515053e-06 0.017940000000000001 5.8606656732349186e-06 0.017950000000000001 4.5422630536085773e-06 0.01796 -7.9533242825052775e-06 0.01797 -3.3622965439670887e-06 0.017980000000000003 -2.4663832549456731e-06 0.017990000000000003 1.9870096657288549e-06 0.018000000000000002 -1.3047837643626975e-07 0.018010000000000002 -8.755770990161791e-06 0.018020000000000001 1.2596999315581403e-06 0.018030000000000001 -1.5552302420434277e-07 0.01804 2.2249790588427532e-06 0.01805 -2.5338746703671956e-07 0.018060000000000003 -2.4934621010046502e-06 0.018070000000000003 1.4603975267923517e-07 0.018080000000000002 1.8885291211691352e-07 0.018090000000000002 1.8973961776950143e-06 0.018100000000000002 6.5336660224185609e-06 0.018110000000000001 7.546883343384753e-07 0.018120000000000001 8.791397050005202e-06 0.01813 -2.3031891991206862e-06 0.01814 -6.5064662228636491e-06 0.018150000000000003 3.746034678888023e-06 0.018160000000000003 -3.5002210512573233e-06 0.018170000000000002 -1.0672363144076098e-05 0.018180000000000002 2.4433836638325897e-06 0.018190000000000001 -8.5268318751735206e-06 0.018200000000000001 -5.6040931506981544e-06 0.01821 1.0570108906934373e-05 0.01822 7.7923556118621594e-06 0.018230000000000003 -7.4521629640306866e-06 0.018240000000000003 -6.9951080304448006e-06 0.018250000000000002 3.4657738490194621e-06 0.018260000000000002 -3.4176935752585039e-06 0.018270000000000002 -7.4518567341380144e-06 0.018280000000000001 -9.1455081956305128e-07 0.018290000000000001 9.9095453817637403e-07 0.0183 -1.3798220167396975e-06 0.01831 -2.1214502974785058e-06 0.018320000000000003 -1.9464309070108066e-06 0.018330000000000003 -1.0809743178108926e-06 0.018340000000000002 -1.7161970623926649e-06 0.018350000000000002 8.7498660657464003e-06 0.018360000000000001 2.4348266646845425e-06 0.018370000000000001 -3.9093579985053683e-06 0.018380000000000001 -5.6214926699313253e-06 0.01839 -9.339447102888656e-06 0.018400000000000003 -1.2842162912454715e-08 0.018410000000000003 3.8020100661057513e-06 0.018420000000000002 5.7238169847545919e-06 0.018430000000000002 -1.7797614591318616e-06 0.018440000000000002 3.2537645096600805e-06 0.018450000000000001 7.9059807865887122e-06 0.018460000000000001 -6.4794721475462465e-07 0.01847 -2.2799361425719406e-07 0.01848 -3.1456766333651373e-06 0.018490000000000003 -4.506881857941908e-06 0.018500000000000003 -1.0357000836019562e-07 0.018510000000000002 -2.6033662338087142e-06 0.018520000000000002 9.0638741952162325e-06 0.018530000000000001 -4.7480284652707654e-06 0.018540000000000001 -2.3083683089181592e-06 0.018550000000000001 -1.8592636163933014e-06 0.01856 6.0015539356447383e-06 0.018570000000000003 3.8802547021374849e-07 0.018580000000000003 -2.8696230635476851e-06 0.018590000000000002 -1.2757252964418676e-06 0.018600000000000002 1.5319870652456291e-06 0.018610000000000002 -6.2664445331632354e-06 0.018620000000000001 -3.4224146999775206e-06 0.018630000000000001 -6.789951174267966e-06 0.01864 4.6579031988628401e-06 0.01865 4.9174158577129535e-06 0.018660000000000003 1.8821986558520674e-07 0.018670000000000003 2.093896683284193e-06 0.018680000000000002 -1.2620241025763031e-06 0.018690000000000002 3.3721858154465672e-06 0.018700000000000001 8.0122743789527405e-06 0.018710000000000001 3.2138368290601551e-06 0.018720000000000001 -5.8367184721317423e-07 0.01873 4.344644001873295e-07 0.018740000000000003 -2.2772779223452239e-06 0.018750000000000003 1.9608239157347744e-06 0.018760000000000002 1.2153104386515875e-05 0.018770000000000002 -6.3027704403079257e-06 0.018780000000000002 -9.405604556849324e-07 0.018790000000000001 -3.5658019123101021e-06 0.018800000000000001 -6.4837284109689163e-07 0.01881 -6.3128844470309495e-07 0.01882 5.6486616426670293e-06 0.018830000000000003 5.7655172612145619e-06 0.018840000000000003 -5.4637435727937173e-06 0.018850000000000002 1.0834011534298624e-06 0.018860000000000002 -4.448349746627211e-06 0.018870000000000001 1.2020546622746638e-05 0.018880000000000001 -7.746135314995906e-06 0.018890000000000001 -9.7591967390783427e-06 0.0189 2.5681629501528122e-07 0.018910000000000003 -1.912028735495733e-06 0.018920000000000003 6.5732484253297836e-06 0.018930000000000002 -5.7240525954768794e-07 0.018940000000000002 -1.1116922105689961e-06 0.018950000000000002 -4.3722957463586254e-06 0.018960000000000001 2.3638557730155989e-06 0.018970000000000001 -8.9297933612920387e-06 0.01898 3.9224625798240792e-06 0.01899 -7.113301595359159e-06 0.019000000000000003 -2.695496225653807e-06 0.019010000000000003 1.8579852342770124e-06 0.019020000000000002 4.178949951242395e-06 0.019030000000000002 6.8439951497766455e-06 0.019040000000000001 -7.0507910003406028e-07 0.019050000000000001 3.7019218674977516e-06 0.019060000000000001 5.192604181969607e-06 0.01907 -8.3953557353375445e-06 0.019080000000000003 4.874666381839524e-06 0.019090000000000003 9.1623931893527347e-07 0.019100000000000002 -3.387417453739812e-07 0.019110000000000002 -3.9664819037987954e-06 0.019120000000000002 4.7507424775577937e-07 0.019130000000000001 3.5645207543439272e-06 0.019140000000000001 -7.8447859103766516e-06 0.01915 9.3463911809630006e-07 0.01916 -4.4908196381900748e-06 0.019170000000000003 -4.3298912405247956e-06 0.019180000000000003 -7.6670159401676433e-07 0.019190000000000002 8.3800594110418035e-06 0.019200000000000002 4.1236828549170164e-06 0.019210000000000001 -3.0983934528571387e-06 0.019220000000000001 -1.1732382074965473e-06 0.019230000000000001 1.0620757014201218e-06 0.01924 1.4532890111314339e-06 0.019250000000000003 8.9667107953535417e-06 0.019260000000000003 -1.4574768278117412e-06 0.019270000000000002 4.0104350318187864e-06 0.019280000000000002 3.8571275622237257e-06 0.019290000000000002 -5.172481398702666e-06 0.019300000000000001 -1.2523738104407779e-05 0.019310000000000001 3.8244729946325062e-06 0.01932 -6.7242579733813394e-06 0.01933 -4.7948300726895577e-06 0.019340000000000003 5.6779781290175965e-06 0.019350000000000003 7.5153634655262669e-07 0.019360000000000002 -2.8202446427562238e-07 0.019370000000000002 4.5894554109520876e-06 0.019380000000000001 1.9359802732400547e-06 0.019390000000000001 6.6794279083648791e-07 0.019400000000000001 -8.4150549923308669e-07 0.01941 3.3323061580558334e-06 0.019420000000000003 9.7570938025479129e-06 0.019430000000000003 -3.9272021078216181e-06 0.019440000000000002 -3.9640186255077588e-06 0.019450000000000002 -2.9946826694714247e-06 0.019460000000000002 3.136795095505402e-06 0.019470000000000001 -1.9999595825186896e-06 0.019480000000000001 -5.0739812035367518e-06 0.01949 1.0126060427080333e-05 0.0195 -2.9118323337654858e-06 0.019510000000000003 6.1940151234267676e-06 0.019520000000000003 6.5730310952369452e-07 0.019530000000000002 -5.8771622162405595e-06 0.019540000000000002 -3.274396351380394e-06 0.019550000000000001 -6.4855176516209681e-06 0.019560000000000001 -9.3231984286104267e-06 0.019570000000000001 -8.5689022340867206e-06 0.01958 3.4940536301972599e-06 0.019590000000000003 -3.6819123438046074e-06 0.019600000000000003 -8.2689989856082738e-06 0.019610000000000002 -2.7216369057817659e-06 0.019620000000000002 6.2049682866685735e-07 0.019630000000000002 -7.1844705695603412e-07 0.019640000000000001 -2.7952861543786047e-07 0.019650000000000001 5.4510256746036005e-06 0.01966 2.204417082411555e-06 0.01967 6.3918220360654818e-06 0.019680000000000003 -5.4240677557527458e-06 0.019690000000000003 -2.1417873139410663e-06 0.019700000000000002 -1.2739515363623035e-05 0.019710000000000002 7.6414385839473717e-06 0.019720000000000001 -3.0174136013841203e-06 0.019730000000000001 2.5737454358967743e-06 0.019740000000000001 6.2561498256547903e-06 0.01975 4.8700565338056951e-06 0.019760000000000003 -1.6241727821816994e-06 0.019770000000000003 -6.8874572879840103e-06 0.019780000000000002 -1.342776016465094e-06 0.019790000000000002 1.2626985256352592e-05 0.019800000000000002 -4.8142321361312489e-07 0.019810000000000001 -6.2110872194056763e-06 0.019820000000000001 2.0750741360465839e-06 0.01983 8.4661447371738286e-07 0.01984 -3.7909243002526471e-06 0.019850000000000003 -7.923162717739741e-06 0.019860000000000003 8.4214312729280596e-06 0.019870000000000002 -9.0686172710747739e-07 0.019880000000000002 -3.805105313909928e-06 0.019890000000000001 -6.2028572359546183e-06 0.019900000000000001 -6.8905111574191552e-06 0.019910000000000001 7.4549989546693424e-06 0.01992 -4.2150274344982515e-06 0.019930000000000003 -5.6076974230945854e-07 0.019940000000000003 5.512456652076067e-06 0.019950000000000002 1.0973402373052897e-06 0.019960000000000002 1.2857806867684e-07 0.019970000000000002 4.489997557615248e-06 0.019980000000000001 3.0942598388714423e-06 0.019990000000000001 4.0228568658220622e-06 0.02 3.4260251809939078e-06 0.02001 5.5385496902285617e-06 0.020020000000000003 -5.842600667904542e-06 0.020030000000000003 -4.7866031459530746e-06 0.020040000000000002 -1.9336274386215394e-06 0.020050000000000002 2.403344578855364e-06 0.020060000000000001 -1.6652495866570958e-07 0.020070000000000001 2.1040091013144796e-06 0.020080000000000001 5.7469509541582062e-07 0.02009 5.4881651145356362e-06 0.020100000000000003 -7.1807296414758874e-07 0.020110000000000003 -2.3524030240988823e-06 0.020120000000000002 8.6308901855199731e-07 0.020130000000000002 -2.5627282797974356e-06 0.020140000000000002 -3.0968398151427325e-06 0.020150000000000001 7.2780612355110022e-06 0.020160000000000001 2.6896438097678951e-06 0.02017 -6.6724567944113826e-06 0.02018 -2.4065621583659997e-06 0.020190000000000003 5.9586348650520313e-06 0.020200000000000003 6.7273641283747414e-06 0.020210000000000002 -4.8174895733876694e-06 0.020220000000000002 6.9518290374923094e-06 0.020230000000000001 -4.9266107100071495e-06 0.020240000000000001 1.1089068823609404e-05 0.020250000000000001 1.5116606323643057e-06 0.02026 7.1786660763140813e-06 0.020270000000000003 4.0586501111200727e-07 0.020280000000000003 3.0097186049634948e-06 0.020290000000000002 3.4184306847207438e-06 0.020300000000000002 -6.5100295048646146e-06 0.020310000000000002 -6.2045475656398361e-06 0.020320000000000001 -2.5951498655204071e-07 0.020330000000000001 3.6751990527661247e-06 0.02034 -2.4085453377896311e-06 0.02035 -2.1608645629107509e-06 0.020360000000000003 1.1817768642218324e-05 0.020370000000000003 4.35599309752028e-06 0.020380000000000002 -5.2139090476333639e-07 0.020390000000000002 -4.2197458069666695e-06 0.020400000000000001 -1.4028101121124555e-06 0.020410000000000001 -1.0433832019160024e-06 0.020420000000000001 -4.3513148840862935e-06 0.02043 2.8506496910081233e-06 0.020440000000000003 1.5391491971038431e-06 0.020450000000000003 -5.4223079952144374e-06 0.020460000000000002 -2.3064031851262563e-06 0.020470000000000002 -1.017144322820289e-06 0.020480000000000002 7.281600277049016e-06 0.020490000000000001 6.9936674173371262e-06 0.020500000000000001 1.6542727442513858e-06 0.02051 4.9776045676364908e-06 0.02052 -5.1444208645560489e-06 0.020530000000000003 1.970167858652078e-06 0.020540000000000003 -5.2748255029684122e-06 0.020550000000000002 2.634894623672606e-06 0.020560000000000002 -1.0867459000024576e-06 0.020570000000000001 -4.3415697119134878e-06 0.020580000000000001 7.6727857838297368e-06 0.020590000000000001 6.8535705026589542e-06 0.0206 -1.2606915810253349e-06 0.020610000000000003 -4.5123003267995734e-06 0.020620000000000003 -3.7120769978904365e-06 0.020630000000000003 -8.5781633651049451e-06 0.020640000000000002 2.5506940530534337e-06 0.020650000000000002 5.6197293403091754e-06 0.020660000000000001 -2.3268075495661933e-06 0.020670000000000001 -7.8625250588995436e-06 0.02068 -1.6118174023893671e-06 0.02069 2.2763485985242482e-06 0.020700000000000003 1.1959217243416644e-06 0.020710000000000003 -2.6354294419428342e-06 0.020720000000000002 -2.974277850711522e-06 0.020730000000000002 8.3892858524890567e-07 0.020740000000000001 3.002776385096478e-06 0.020750000000000001 -1.9107514254599714e-06 0.020760000000000001 -1.6291990355443951e-06 0.02077 2.8676127370384627e-06 0.020780000000000003 -2.3981876653752511e-06 0.020790000000000003 8.2642336925249311e-07 0.020800000000000003 -1.4455902942132973e-08 0.020810000000000002 9.922871330100361e-06 0.020820000000000002 -4.2641726569481997e-06 0.020830000000000001 4.0841697502089304e-06 0.020840000000000001 -8.6535716085454273e-06 0.02085 -4.9958098006560749e-06 0.02086 3.0772130233864993e-07 0.020870000000000003 -2.5552939430281563e-06 0.020880000000000003 7.0216046589687893e-06 0.020890000000000002 4.2918671727862883e-06 0.020900000000000002 -1.0051345185227366e-06 0.020910000000000002 6.3385213075719207e-06 0.020920000000000001 2.2972670332191246e-06 0.020930000000000001 4.2292782228399419e-06 0.02094 -4.1072308011512992e-06 0.020950000000000003 -3.4439262644520777e-06 0.020960000000000003 -9.3576481140368246e-06 0.020970000000000003 2.7326920480023883e-06 0.020980000000000002 -2.4243137299528379e-06 0.020990000000000002 -2.9811850998106599e-06 0.021000000000000001 1.3522699156954621e-06 0.021010000000000001 3.8256490143409811e-06 0.02102 -5.0964316139012145e-06 0.02103 -1.2813967833845123e-06 0.021040000000000003 1.1017457496533756e-06 0.021050000000000003 -5.0383981038255337e-07 0.021060000000000002 3.3100477776561872e-06 0.021070000000000002 -5.7049253236069405e-06 0.021080000000000002 1.3750788404949117e-07 0.021090000000000001 -2.6003820419371417e-06 0.021100000000000001 2.9206940691375686e-06 0.02111 -2.7149939729028567e-06 0.021120000000000003 1.5746913700745639e-06 0.021130000000000003 9.1393069920415392e-06 0.021140000000000003 -2.4406279898976916e-06 0.021150000000000002 -2.5252382815295208e-07 0.021160000000000002 9.4754900361893515e-07 0.021170000000000001 3.8814795106975456e-06 0.021180000000000001 -1.0467365749053729e-05 0.021190000000000001 4.5671944389264919e-06 0.0212 9.6090409672268361e-06 0.021210000000000003 -1.2295432442979366e-06 0.021220000000000003 -3.1771753986263031e-06 0.021230000000000002 1.0237469115244509e-06 0.021240000000000002 -2.2104371158563191e-06 0.021250000000000002 -9.4864061117654363e-07 0.021260000000000001 -3.7220259135071245e-06 0.021270000000000001 3.674900123975252e-06 0.02128 -5.3846774643910115e-06 0.021290000000000003 1.5120998860251693e-06 0.021300000000000003 -5.8090611627918847e-06 0.021310000000000003 -7.3893344328732385e-06 0.021320000000000002 1.192474025801387e-05 0.021330000000000002 -4.0283451036772044e-06 0.021340000000000001 4.4809292782162486e-06 0.021350000000000001 -2.9516024744945045e-07 0.021360000000000001 4.0193349205222028e-06 0.02137 8.9624386712344961e-06 0.021380000000000003 1.4916253392549653e-06 0.021390000000000003 1.2682557187971856e-06 0.021400000000000002 1.4798807338171461e-06 0.021410000000000002 7.4882278304751068e-06 0.021420000000000002 2.6735545692449704e-06 0.021430000000000001 -1.3166003077678195e-06 0.021440000000000001 -3.6602617182114382e-06 0.02145 -8.2602057957237008e-06 0.021460000000000003 -2.5036452582836897e-06 0.021470000000000003 4.7486609947201647e-07 0.021480000000000003 -3.9665555922985936e-06 0.021490000000000002 -9.3056316642427207e-07 0.021500000000000002 -3.1041851723645493e-06 0.021510000000000001 -3.8602658875681572e-06 0.021520000000000001 -7.8020037112314094e-07 0.021530000000000001 -3.3923900403063093e-06 0.02154 2.3380111723962795e-06 0.021550000000000003 1.6617773487367017e-06 0.021560000000000003 -1.3784470104717515e-06 0.021570000000000002 1.5523253277429051e-06 0.021580000000000002 1.5760926207722268e-06 0.021590000000000002 -2.5518203431745321e-06 0.021600000000000001 3.8402944993984841e-06 0.021610000000000001 -1.9399120348432188e-06 0.02162 3.3516291613358198e-06 0.021630000000000003 1.0342951700083996e-06 0.021640000000000003 4.3404101914457784e-06 0.021650000000000003 -9.8132621010660654e-07 0.021660000000000002 2.517697091197411e-06 0.021670000000000002 4.520063940433183e-06 0.021680000000000001 -1.4548130383788841e-06 0.021690000000000001 -5.2276720705120531e-06 0.021700000000000001 1.0317506890823299e-05 0.02171 1.2246557794736933e-06 0.021720000000000003 8.4949713272407232e-06 0.021730000000000003 -3.3094606851459572e-06 0.021740000000000002 2.6081530935508453e-06 0.021750000000000002 -4.870988858986433e-06 0.021760000000000002 3.2410724269876166e-06 0.021770000000000001 -5.676311397038523e-06 0.021780000000000001 7.4561891959368512e-06 0.02179 2.1439333856438223e-06 0.021800000000000003 -7.4133572614245622e-07 0.021810000000000003 2.6967104042630927e-06 0.021820000000000003 4.5760770747160348e-06 0.021830000000000002 -6.6956177597044117e-06 0.021840000000000002 5.9806256551442111e-06 0.021850000000000001 8.580581389437038e-08 0.021860000000000001 8.1827110551048877e-06 0.021870000000000001 -4.8851980557424537e-06 0.02188 8.3060376142988214e-06 0.021890000000000003 3.8412998355500212e-06 0.021900000000000003 7.2565988673782963e-06 0.021910000000000002 8.4372030644842856e-06 0.021920000000000002 3.566897759742189e-06 0.021930000000000002 -7.2330820803115163e-06 0.021940000000000001 1.2038659388490418e-06 0.021950000000000001 3.6702918453696018e-06 0.02196 -4.5048993535469926e-07 0.021970000000000003 -4.3514233864138038e-06 0.021980000000000003 -1.9674043171079043e-06 0.021990000000000003 -1.377126351464118e-06 0.022000000000000002 1.9453024381936601e-06 0.022010000000000002 -7.7459296878365717e-06 0.022020000000000001 -1.0216902024897809e-05 0.022030000000000001 -7.160589796255302e-06 0.022040000000000001 3.3959527502656343e-06 0.02205 -6.6732363980566496e-06 0.022060000000000003 -8.6747246600140737e-06 0.022070000000000003 2.3252297479369855e-06 0.022080000000000002 -5.6400516593634691e-06 0.022090000000000002 -7.2608447547737734e-06 0.022100000000000002 2.4484788108014595e-07 0.022110000000000001 -2.9705651534659344e-07 0.022120000000000001 1.4770246140609721e-06 0.02213 1.5060634395521889e-06 0.022140000000000003 -4.9304618182374105e-06 0.022150000000000003 -4.2596978605460571e-06 0.022160000000000003 4.2968169753256422e-06 0.022170000000000002 1.0474240370251672e-06 0.022180000000000002 9.6997549342803078e-06 0.022190000000000001 -1.0644982378645294e-05 0.022200000000000001 -5.1185929310903923e-06 0.022210000000000001 1.2971174935602349e-07 0.02222 -1.0939319341272745e-05 0.022230000000000003 6.0414366867235971e-06 0.022240000000000003 1.4349350204851764e-06 0.022250000000000002 -3.2947541528186124e-06 0.022260000000000002 -9.8547750483961753e-06 0.022270000000000002 3.143868993963401e-06 0.022280000000000001 4.5671133599654945e-06 0.022290000000000001 -2.2227584227822233e-07 0.0223 3.7081633846016569e-06 0.022310000000000003 -2.5296217397849243e-06 0.022320000000000003 -3.8714860539241937e-06 0.022330000000000003 -9.8425876358613357e-06 0.022340000000000002 4.7808412594241457e-06 0.022350000000000002 3.016928010849342e-06 0.022360000000000001 -3.1318034823860107e-06 0.022370000000000001 -5.4644297571140826e-06 0.022380000000000001 6.2866565926398762e-06 0.02239 -1.8489853321200503e-06 0.022400000000000003 -6.7892749434662677e-06 0.022410000000000003 2.4723119109909132e-06 0.022420000000000002 -1.5299711797758279e-06 0.022430000000000002 -2.6156804028347354e-06 0.022440000000000002 6.4659946037612129e-06 0.022450000000000001 1.7086490875070908e-06 0.022460000000000001 5.831718513321317e-06 0.02247 4.5504646975806225e-06 0.022480000000000003 -3.5551362838373705e-06 0.022490000000000003 -2.8798205444459289e-06 0.022500000000000003 -2.2217580764278495e-06 0.022510000000000002 -6.3766899065191584e-07 0.022520000000000002 -2.8212289397356098e-07 0.022530000000000001 5.073785118636774e-06 0.022540000000000001 7.0235209556947361e-06 0.022550000000000001 3.6308944219596132e-06 0.02256 -4.9346708803776376e-06 0.022570000000000003 -2.98415553749513e-07 0.022580000000000003 -4.7092817494905444e-06 0.022590000000000002 3.6331118927909843e-06 0.022600000000000002 4.6583941515741069e-06 0.022610000000000002 -6.7057595469625528e-06 0.022620000000000001 -1.4192721621936708e-06 0.022630000000000001 2.4870483415665333e-06 0.02264 7.7528991854473527e-06 0.022650000000000003 3.9441082588716038e-06 0.022660000000000003 5.9849342974750172e-06 0.022670000000000003 5.1741843079287355e-06 0.022680000000000002 2.4932097991144288e-06 0.022690000000000002 3.8111077669685748e-06 0.022700000000000001 7.7565302346556801e-06 0.022710000000000001 -2.0498333608968992e-06 0.022720000000000001 -8.7702776476614866e-06 0.02273 -6.5972714071216183e-06 0.022740000000000003 -9.3745260323493818e-06 0.022750000000000003 1.9434732446686923e-06 0.022760000000000002 -9.0714952444623237e-06 0.022770000000000002 -4.23456007051703e-06 0.022780000000000002 1.0582917461069251e-05 0.022790000000000001 -3.7467377320005405e-06 0.022800000000000001 1.2436727644157762e-06 0.02281 -1.7405612053418812e-06 0.022820000000000003 8.6065411436634002e-08 0.022830000000000003 2.4623546315688333e-07 0.022840000000000003 5.9791577134097296e-07 0.022850000000000002 1.0884784278141736e-05 0.022860000000000002 -2.6348669714314363e-06 0.022870000000000001 1.859236150882822e-06 0.022880000000000001 -3.4842393266685167e-06 0.022890000000000001 -6.2570143966486617e-06 0.0229 -1.5071584026829002e-06 0.022910000000000003 2.2269651361104554e-06 0.022920000000000003 2.2077634614544283e-06 0.022930000000000002 9.3575601467021726e-07 0.022940000000000002 -7.1989148151090189e-06 0.022950000000000002 -2.7516998601866884e-06 0.022960000000000001 -1.3576565666770567e-06 0.022970000000000001 8.819119303651095e-06 0.02298 4.2710084896972962e-06 0.022990000000000003 1.6939235801195926e-06 0.023000000000000003 -5.5975957585913303e-06 0.023010000000000003 -4.7978123176007019e-06 0.023020000000000002 -8.1971250455991309e-06 0.023030000000000002 -2.635179488246647e-06 0.023040000000000001 -1.5579754632699418e-06 0.023050000000000001 -7.3198224555759236e-06 0.023060000000000001 -5.565219458748837e-06 0.02307 2.4180513523765543e-06 0.023080000000000003 -4.3843356031472975e-06 0.023090000000000003 -4.2263192128428099e-07 0.023100000000000002 2.1695363007723747e-06 0.023110000000000002 3.4065315668513493e-06 0.023120000000000002 1.1916300289165872e-05 0.023130000000000001 -1.094974155869826e-05 0.023140000000000001 4.2218166630663404e-06 0.02315 -6.3965589861097269e-07 0.023160000000000004 -3.4767452625266077e-07 0.023170000000000003 -3.1922297460877461e-06 0.023180000000000003 9.897819457837404e-07 0.023190000000000002 5.9906846637725195e-06 0.023200000000000002 -4.3202945897692149e-06 0.023210000000000001 1.167752105395844e-06 0.023220000000000001 8.8474389232115584e-06 0.023230000000000001 -5.8619540817647546e-07 0.02324 3.6793965307825015e-06 0.023250000000000003 -4.8015221771113958e-06 0.023260000000000003 1.844181287908935e-06 0.023270000000000002 4.7627117520269954e-06 0.023280000000000002 7.1542955513154722e-06 0.023290000000000002 -5.7212312770185323e-07 0.023300000000000001 3.6027697260042377e-07 0.023310000000000001 -1.0424917569455753e-05 0.02332 3.6363446391769046e-06 0.023330000000000004 5.4255155608219859e-06 0.023340000000000003 -8.1474936055014366e-08 0.023350000000000003 -4.1269446995152593e-06 0.023360000000000002 -2.5306353769899816e-06 0.023370000000000002 -6.3724865676543114e-06 0.023380000000000001 -3.7847718508525447e-08 0.023390000000000001 9.4249094840394576e-06 0.023400000000000001 -4.563719546700783e-06 0.02341 3.6107610051806862e-06 0.023420000000000003 -5.4142586768004559e-06 0.023430000000000003 -1.3762730955384664e-06 0.023440000000000003 -1.6555853295004062e-06 0.023450000000000002 8.7822481479053222e-06 0.023460000000000002 2.4285125485031913e-06 0.023470000000000001 -6.0048615911671226e-08 0.023480000000000001 1.0255329871142451e-06 0.02349 -1.2785731169877496e-05 0.023500000000000004 -6.4570615719646003e-06 0.023510000000000003 -6.5757788690697753e-06 0.023520000000000003 -1.282322179470997e-06 0.023530000000000002 -2.4450735840384017e-07 0.023540000000000002 1.1452445101856878e-06 0.023550000000000001 -1.2864056664757027e-06 0.023560000000000001 -1.1699637920637656e-05 0.023570000000000001 2.0975107222622371e-06 0.02358 -4.327523204516599e-06 0.023590000000000003 4.4667652025482962e-06 0.023600000000000003 2.0944932153924156e-06 0.023610000000000003 -5.9527127272656226e-06 0.023620000000000002 6.9018365032885474e-06 0.023630000000000002 -1.339297108790961e-05 0.023640000000000001 5.913998596388446e-06 0.023650000000000001 -9.8543051433489847e-06 0.02366 8.3535142541907861e-07 0.023670000000000004 -5.0682958359521623e-08 0.023680000000000003 -2.6937155001081606e-06 0.023690000000000003 6.4258887631701136e-06 0.023700000000000002 -3.2287046467354971e-06 0.023710000000000002 4.8149696898761286e-06 0.023720000000000001 1.7331807222706015e-06 0.023730000000000001 -1.0447852132479763e-06 0.023740000000000001 9.4492042670819687e-07 0.02375 -2.5879815828737491e-06 0.023760000000000003 -2.2138261647001087e-06 0.023770000000000003 -6.6654731838156502e-06 0.023780000000000003 3.1649815208363117e-06 0.023790000000000002 3.3654243251088963e-06 0.023800000000000002 1.3321633264344492e-05 0.023810000000000001 2.4357326721157078e-06 0.023820000000000001 -2.2159590997537289e-06 0.02383 -7.5665523680063787e-06 0.023840000000000004 8.4213589528784898e-06 0.023850000000000003 1.8750827930635558e-06 0.023860000000000003 6.8063737513023924e-06 0.023870000000000002 6.4207654055007203e-06 0.023880000000000002 7.483295081065536e-06 0.023890000000000002 -4.2632937564150886e-06 0.023900000000000001 6.059297127075834e-06 0.023910000000000001 3.0886752446396646e-06 0.02392 -3.2799601079742833e-06 0.023930000000000003 -4.6863606646235037e-06 0.023940000000000003 6.2008287596655703e-06 0.023950000000000003 -5.8874137315331646e-06 0.023960000000000002 -5.4576795447525741e-06 0.023970000000000002 1.7762298169414309e-06 0.023980000000000001 4.9068938162555422e-06 0.023990000000000001 1.1930891034628155e-05 0.024 6.3088326628523487e-06)
Vcornoise1 cornoise1 0 PWL(0 -1.5390068177419963e-06 1.0000000000000001e-05 -7.7565776270555415e-06 2.0000000000000002e-05 4.7923980228614671e-06 3.0000000000000004e-05 -8.0029931819664705e-06 4.0000000000000003e-05 -2.1694293997003382e-06 5.0000000000000002e-05 -5.9245059238782531e-06 6.0000000000000008e-05 2.965587025510538e-06 7.0000000000000007e-05 -6.7254261253516898e-07 8.0000000000000007e-05 1.1094749926228196e-05 9.0000000000000006e-05 -2.5067172419979923e-06 0.0001 3.7350102925741404e-06 0.00011 7.1023227476077912e-07 0.00012000000000000002 1.0133253534752878e-06 0.00013000000000000002 -1.7579037300882813e-05 0.00014000000000000001 5.5811215363957634e-06 0.00015000000000000001 3.1456904479133399e-06 0.00016000000000000001 -5.2914116688008919e-06 0.00017000000000000001 7.9120279878984279e-07 0.00018000000000000001 -4.9243292600255917e-06 0.00019000000000000001 2.9463789031791319e-06 0.00020000000000000001 7.1345641396264373e-07 0.00021000000000000001 -2.0936436317183946e-06 0.00022000000000000001 -2.7554887291538769e-06 0.00023000000000000001 2.3033464837012986e-06 0.00024000000000000003 2.5497588852699155e-06 0.00025000000000000001 -1.3517125363634827e-05 0.00026000000000000003 -3.0765967159169631e-06 0.00027 4.603250688590312e-06 0.00028000000000000003 3.5309545703857922e-07 0.00029 5.0526426334038582e-06 0.00030000000000000003 2.9448311278128676e-06 0.00031 -1.1317135902498142e-06 0.00032000000000000003 -1.7478720171484602e-06 0.00033000000000000005 3.494771270015365e-07 0.00034000000000000002 -6.3899861536581023e-07 0.00035000000000000005 3.6174410842578066e-06 0.00036000000000000002 -7.0143358250450619e-06 0.00037000000000000005 -1.4413568518540362e-06 0.00038000000000000002 5.1358906754995694e-06 0.00039000000000000005 1.8497912639641876e-06 0.00040000000000000002 1.3271309114674016e-06 0.00041000000000000005 -3.5767538606088059e-06 0.00042000000000000002 -3.6061263232360376e-06 0.00043000000000000004 -6.9565215530139226e-06 0.00044000000000000002 3.6056535985299407e-06 0.00045000000000000004 1.6507615380845237e-06 0.00046000000000000001 -9.8245413268182888e-06 0.00047000000000000004 1.0457493219472427e-05 0.00048000000000000007 -1.7404814377281949e-06 0.00049000000000000009 1.3119000788427492e-05 0.00050000000000000001 3.9305677996423837e-06 0.00051000000000000004 9.7126801285804532e-06 0.00052000000000000006 -6.9468068812759489e-06 0.00053000000000000009 3.962400185275415e-06 0.00054000000000000001 -4.823880030492904e-06 0.00055000000000000003 -6.4350049288149189e-06 0.00056000000000000006 7.2963609636691311e-07 0.00057000000000000009 2.3750265461879702e-06 0.00058 6.4236612048414801e-06 0.00059000000000000003 3.1754313085513678e-06 0.00060000000000000006 5.6137527641968417e-06 0.00061000000000000008 -5.9705765651905871e-07 0.00062 2.8691460657345126e-07 0.00063000000000000003 -5.4674617598357338e-07 0.00064000000000000005 -8.5897548524987349e-08 0.00065000000000000008 3.3499843475460866e-06 0.0006600000000000001 9.1226028026449261e-06 0.00067000000000000002 2.5033692194460351e-06 0.00068000000000000005 -7.1315792736076294e-07 0.00069000000000000008 2.5648914906517318e-06 0.0007000000000000001 -1.4378324214366357e-06 0.00071000000000000002 -8.2603863729796786e-07 0.00072000000000000005 4.1882278636127673e-06 0.00073000000000000007 2.183133927256154e-06 0.0007400000000000001 9.039782083036617e-06 0.00075000000000000002 -2.8575110939417559e-06 0.00076000000000000004 -1.3834928007606348e-06 0.00077000000000000007 8.0933449033427163e-06 0.00078000000000000009 -1.2249638799206571e-06 0.00079000000000000001 1.1009999286294673e-05 0.00080000000000000004 3.4538626830379516e-07 0.00081000000000000006 3.0024628795503785e-06 0.00082000000000000009 -3.0469991116684552e-06 0.00083000000000000012 6.0778410713498662e-06 0.00084000000000000003 -4.7638225755965258e-06 0.00085000000000000006 -4.8203952030352731e-06 0.00086000000000000009 4.1409594493427269e-06 0.00087000000000000011 4.9916707641577169e-06 0.00088000000000000003 8.0161717747391825e-07 0.00089000000000000006 4.1468455924656378e-06 0.00090000000000000008 4.0280179283384726e-07 0.00091000000000000011 4.5102551585813365e-06 0.00092000000000000003 -1.0100488778928375e-06 0.00093000000000000005 -2.1580051876821256e-06 0.00094000000000000008 -2.6792142435465719e-06 0.00095000000000000011 5.6555875133195032e-07 0.00096000000000000013 -6.153280397206745e-07 0.00097000000000000005 8.9215458010805194e-06 0.00098000000000000019 5.9304751938786911e-06 0.00098999999999999999 6.7092273522249577e-06 0.001 -3.523815497344835e-06 0.00101 4.2663728006348969e-06 0.0010200000000000001 -1.0977786864308866e-06 0.0010300000000000001 2.0404424637399277e-06 0.0010400000000000001 6.1228123960735084e-08 0.0010500000000000002 7.5837379565503867e-06 0.0010600000000000002 -8.1297430014929671e-06 0.00107 -5.9171947480295554e-06 0.00108 7.0917862891272131e-07 0.00109 -5.1536419945776161e-06 0.0011000000000000001 -3.4299872098656133e-06 0.0011100000000000001 2.9082659242466516e-06 0.0011200000000000001 4.7217434367693368e-06 0.0011300000000000001 -1.385466288659347e-06 0.0011400000000000002 4.3058169244959915e-06 0.0011500000000000002 -1.5134972051295068e-06 0.00116 -7.3199728582969103e-06 0.00117 -4.8989495055821735e-06 0.0011800000000000001 -1.6413895601914008e-06 0.0011900000000000001 -2.0503802398432792e-06 0.0012000000000000001 -3.6115162086648133e-06 0.0012100000000000001 2.6257507591624416e-06 0.0012200000000000002 9.8887339289351372e-06 0.0012300000000000002 2.283789668593295e-07 0.00124 -7.9995598336278099e-07 0.00125 1.6053440336161611e-06 0.0012600000000000001 -1.1285815554134912e-06 0.0012700000000000001 -3.9514537959450503e-06 0.0012800000000000001 4.0193349227297249e-06 0.0012900000000000001 4.1610074765215953e-06 0.0013000000000000002 1.0824919992546726e-06 0.0013100000000000002 4.5324648443172199e-06 0.0013200000000000002 4.5657142290232214e-06 0.00133 -2.6494719965587244e-06 0.00134 -4.7529767397020739e-06 0.0013500000000000001 -1.3536059112460224e-06 0.0013600000000000001 -1.5660763584315101e-06 0.0013700000000000001 -3.341670353459529e-06 0.0013800000000000002 4.8712341282793582e-07 0.0013900000000000002 -2.3327209800605095e-06 0.0014000000000000002 1.4777826642304044e-07 0.00141 7.4778336765243849e-06 0.00142 4.5376861428065419e-06 0.0014300000000000001 3.5792568413133867e-06 0.0014400000000000001 -7.8276951286074257e-06 0.0014500000000000001 -1.1172233674750898e-06 0.0014600000000000001 -8.6310003257666623e-07 0.0014700000000000002 8.3984828747780875e-06 0.0014800000000000002 2.0777901807637401e-07 0.0014900000000000002 2.6006371904746097e-06 0.0015 -4.8798925844809443e-06 0.0015100000000000001 -5.2500962093387683e-06 0.0015200000000000001 3.0924366308309456e-06 0.0015300000000000001 2.2207630528112579e-06 0.0015400000000000001 -1.4110584336440381e-06 0.0015500000000000002 -4.2158949413496873e-06 0.0015600000000000002 5.5441474478319683e-06 0.0015700000000000002 -3.8098616309928265e-06 0.00158 6.7516718108859294e-07 0.0015900000000000001 -1.5944166429382962e-06 0.0016000000000000001 -1.5335666563428063e-07 0.0016100000000000001 -3.1157105849373207e-07 0.0016200000000000001 2.1552174961424808e-06 0.0016300000000000002 -6.7739507006779382e-06 0.0016400000000000002 3.6312986836244423e-06 0.0016500000000000002 -2.2760921269307644e-06 0.0016600000000000002 -4.0925408896549638e-06 0.00167 -4.9080970762017027e-06 0.0016800000000000001 8.6878327149385285e-07 0.0016900000000000001 -1.7396088330226115e-06 0.0017000000000000001 -5.1684962206823123e-07 0.0017100000000000001 7.7400523752184404e-07 0.0017200000000000002 1.9902545786663176e-06 0.0017300000000000002 5.7055132327322062e-06 0.0017400000000000002 3.654210112410556e-06 0.00175 -9.3098215184699177e-07 0.0017600000000000001 -6.3850850821385627e-06 0.0017700000000000001 -2.2588552742122731e-06 0.0017800000000000001 -3.9946545087280212e-06 0.0017900000000000001 -2.8321275830071927e-06 0.0018000000000000002 -6.8559684149939322e-06 0.0018100000000000002 -6.7090327975344845e-06 0.0018200000000000002 -1.2056733161874996e-06 0.0018300000000000002 -5.5137362193099095e-06 0.0018400000000000001 1.8089079419827609e-06 0.0018500000000000001 7.8506570386023254e-06 0.0018600000000000001 -1.1570612143988405e-05 0.0018700000000000001 -1.0293092934464911e-05 0.0018800000000000002 -1.5902792912949696e-05 0.0018900000000000002 -4.9506893580774498e-06 0.0019000000000000002 -5.291842320949768e-06 0.0019100000000000002 -6.2218143211857281e-06 0.0019200000000000003 1.6858737647150711e-06 0.0019300000000000001 4.5746415976276762e-06 0.0019400000000000001 -4.5931974918546925e-06 0.0019500000000000001 -3.7141947529602901e-06 0.0019600000000000004 2.5796462014349472e-06 0.00197 -1.7690333762372544e-06 0.00198 -1.1020348732209568e-06 0.00199 -7.8219807043153681e-07 0.002 -7.9244438063508982e-07 0.0020100000000000001 -3.7848732264335382e-06 0.0020200000000000001 -7.1779061834645658e-06 0.0020300000000000001 -1.6694189878870932e-06 0.0020400000000000001 -4.208330079077858e-06 0.0020500000000000002 -5.1749141019703783e-06 0.0020600000000000002 1.8718132463031935e-06 0.0020700000000000002 8.5648395030359353e-07 0.0020800000000000003 2.1326238986881404e-06 0.0020900000000000003 -2.3484108204292523e-06 0.0021000000000000003 3.7156818741198687e-06 0.0021100000000000003 1.1433415317927342e-06 0.0021200000000000004 -3.0080097265304274e-06 0.0021300000000000004 -2.7595195116394656e-06 0.00214 2.7417725097655347e-06 0.00215 5.8570874557491771e-06 0.00216 5.3890748098311542e-07 0.0021700000000000001 -8.9464983834814472e-06 0.0021800000000000001 2.7290566696549488e-06 0.0021900000000000001 2.8348353067877058e-06 0.0022000000000000001 -4.7437160077090709e-06 0.0022100000000000002 5.417026176886719e-06 0.0022200000000000002 -2.2967361528653576e-07 0.0022300000000000002 2.2352711373945881e-07 0.0022400000000000002 -1.9641861578790841e-06 0.0022500000000000003 -1.7159427668672356e-07 0.0022600000000000003 -3.2988986610189053e-06 0.0022700000000000003 3.939422461906498e-06 0.0022800000000000003 3.117150867039413e-06 0.0022900000000000004 5.8805504621148087e-06 0.0023000000000000004 -5.8632343039053508e-06 0.00231 -5.5143092236882752e-06 0.00232 -4.1065452135567387e-06 0.00233 -2.946339847441509e-06 0.0023400000000000001 8.7896730591318065e-06 0.0023500000000000001 1.5694021544958291e-06 0.0023600000000000001 -4.036971134053924e-06 0.0023700000000000001 -7.8336941285181876e-06 0.0023800000000000002 -7.2861807940571309e-06 0.0023900000000000002 -1.1668439003430727e-07 0.0024000000000000002 2.8485486291918322e-06 0.0024100000000000002 1.6050678232833386e-06 0.0024200000000000003 3.106663359165556e-06 0.0024300000000000003 3.9903858745299472e-06 0.0024400000000000003 -5.7871483846687607e-06 0.0024500000000000004 3.3735423034520236e-06 0.0024600000000000004 -2.0923313298122562e-06 0.0024700000000000004 2.4153037519965158e-06 0.00248 2.4421477792994957e-06 0.00249 -2.9814281585938898e-06 0.0025000000000000001 -1.1645297943691768e-05 0.0025100000000000001 -6.7122546357697818e-06 0.0025200000000000001 1.1617860728377915e-06 0.0025300000000000001 -1.7029785622902928e-06 0.0025400000000000002 4.0536449868697088e-06 0.0025500000000000002 -8.0422775996103692e-06 0.0025600000000000002 3.4008207943301603e-06 0.0025700000000000002 -5.4470959698232644e-06 0.0025800000000000003 -5.1330541534019655e-06 0.0025900000000000003 4.8134183265355969e-06 0.0026000000000000003 1.4343345672219178e-07 0.0026100000000000003 -1.5061579112392215e-05 0.0026200000000000004 6.7830698424904395e-07 0.0026300000000000004 2.5795742092090979e-06 0.0026400000000000004 4.1574270154166433e-06 0.00265 6.5341131671934764e-07 0.00266 2.6098291680606991e-06 0.0026700000000000001 -1.3390630146098996e-06 0.0026800000000000001 1.9693565390880844e-06 0.0026900000000000001 -2.2052523377343167e-06 0.0027000000000000001 -4.1678728358562285e-06 0.0027100000000000002 -9.398214890013099e-06 0.0027200000000000002 -1.2866352047179031e-06 0.0027300000000000002 -4.2960859658831352e-06 0.0027400000000000002 -9.8147453442733235e-07 0.0027500000000000003 4.0944766408038448e-06 0.0027600000000000003 5.0870024802243912e-06 0.0027700000000000003 -1.6020609442900214e-06 0.0027800000000000004 -6.7010008097509991e-07 0.0027900000000000004 -1.4094517119185444e-06 0.0028000000000000004 -6.600475425518532e-07 0.0028100000000000004 3.9535258225009363e-06 0.00282 -5.9919882163606514e-06 0.0028300000000000001 -1.8464579097685605e-06 0.0028400000000000001 2.6356290271424201e-08 0.0028500000000000001 -3.9195211037523248e-06 0.0028600000000000001 5.078456497844185e-06 0.0028700000000000002 -1.0787075271197478e-06 0.0028800000000000002 1.7522894968591467e-06 0.0028900000000000002 -3.765095654418705e-07 0.0029000000000000002 -1.0895894941255865e-06 0.0029100000000000003 8.4150399159052707e-06 0.0029200000000000003 -1.6094190123516584e-06 0.0029300000000000003 -3.9977766461309439e-06 0.0029400000000000003 9.5138554250038913e-06 0.0029500000000000004 1.8216021582582458e-06 0.0029600000000000004 2.8135654620571967e-06 0.0029700000000000004 1.947290171536265e-06 0.0029800000000000004 -2.4702677524088194e-06 0.00299 -4.5528605146130509e-06 0.0030000000000000001 4.7165009167652477e-06 0.0030100000000000001 -1.2894920669450869e-06 0.0030200000000000001 -1.9761834472450051e-06 0.0030300000000000001 -2.2164863575203717e-07 0.0030400000000000002 -4.0375445109195489e-06 0.0030500000000000002 -4.1168887118575156e-06 0.0030600000000000002 -4.9811144359405975e-06 0.0030700000000000002 -3.4415839783991223e-06 0.0030800000000000003 -4.0098942392780736e-06 0.0030900000000000003 3.5749518202781756e-06 0.0031000000000000003 -9.7382724367705873e-06 0.0031100000000000004 9.9654622789484824e-06 0.0031200000000000004 -1.4027168263338212e-06 0.0031300000000000004 -3.3660379793323222e-06 0.0031400000000000004 1.1935182111319258e-05 0.0031500000000000005 -4.099249272937649e-06 0.00316 4.0814715133492149e-06 0.0031700000000000001 -3.7490331751049027e-06 0.0031800000000000001 -2.2927275383891395e-06 0.0031900000000000001 2.4529452749312513e-06 0.0032000000000000002 2.4071692521035742e-06 0.0032100000000000002 3.3915159662957375e-06 0.0032200000000000002 1.1280381886760241e-06 0.0032300000000000002 4.502243907519146e-07 0.0032400000000000003 -3.1195314270079347e-06 0.0032500000000000003 -8.3269636959057596e-06 0.0032600000000000003 5.6712330802438444e-06 0.0032700000000000003 -8.6850604847512364e-06 0.0032800000000000004 1.4258038454725102e-06 0.0032900000000000004 -3.4444493831483499e-06 0.0033000000000000004 -1.0832327163944432e-05 0.0033100000000000004 2.4811181288759692e-06 0.0033200000000000005 -6.5777651554943122e-06 0.0033300000000000001 8.1298090329717901e-06 0.0033400000000000001 -3.2209027284806583e-06 0.0033500000000000001 -8.0330056166457382e-07 0.0033600000000000001 7.7695686426169039e-06 0.0033700000000000002 -8.4728834114618903e-06 0.0033800000000000002 3.0716848307924158e-06 0.0033900000000000002 1.2327595211083988e-05 0.0034000000000000002 4.8669207322538729e-06 0.0034100000000000003 7.4708284678847307e-06 0.0034200000000000003 -1.0148611604260784e-05 0.0034300000000000003 3.6331789055892276e-07 0.0034400000000000003 4.7908734808493808e-07 0.0034500000000000004 -9.5216721990589385e-06 0.0034600000000000004 1.3750680307389827e-06 0.0034700000000000004 -2.8836316109090247e-06 0.0034800000000000005 -1.1089452394341819e-05 0.0034900000000000005 1.6129811676213254e-06 0.0035000000000000001 -5.1389075011956443e-06 0.0035100000000000001 -2.8434161387154651e-06 0.0035200000000000001 3.2775195873449283e-06 0.0035300000000000002 7.9481169678420342e-06 0.0035400000000000002 -8.5974899630097133e-06 0.0035500000000000002 -1.5228166527221273e-06 0.0035600000000000002 5.0848089523955725e-07 0.0035700000000000003 -2.6892871733495258e-06 0.0035800000000000003 7.184421076472735e-06 0.0035900000000000003 8.1260443735765547e-06 0.0036000000000000003 1.893360916514731e-06 0.0036100000000000004 -4.6772475635749072e-06 0.0036200000000000004 4.8650217872728559e-06 0.0036300000000000004 -3.4132991554128405e-06 0.0036400000000000004 -5.5227670372257737e-06 0.0036500000000000005 1.4834243005899723e-06 0.0036600000000000005 1.6381796601475192e-06 0.0036700000000000001 -9.7526072429409361e-06 0.0036800000000000001 2.8336528688886369e-06 0.0036900000000000001 4.0218615780266144e-06 0.0037000000000000002 1.9986169208273456e-06 0.0037100000000000002 -3.4747732201082779e-06 0.0037200000000000002 -3.2175767293181773e-07 0.0037300000000000002 -1.2886016277143695e-06 0.0037400000000000003 -1.6850953761911257e-06 0.0037500000000000003 -5.2853386650417469e-06 0.0037600000000000003 -2.0028478554485986e-06 0.0037700000000000003 3.4014783441734912e-06 0.0037800000000000004 1.6208648075396827e-06 0.0037900000000000004 5.2317176289858111e-06 0.0038000000000000004 -2.3052013402843745e-06 0.0038100000000000005 1.8716132995958052e-05 0.0038200000000000005 7.5230732814072458e-06 0.0038300000000000005 1.9536392849785441e-06 0.0038400000000000005 -6.8377893618917798e-06 0.0038500000000000001 -3.0441484591043425e-06 0.0038600000000000001 5.9572094294828466e-06 0.0038700000000000002 -3.6304398863573446e-06 0.0038800000000000002 5.0809545781263895e-06 0.0038900000000000002 2.9921925392523549e-06 0.0039000000000000003 6.5517056662736826e-06 0.0039100000000000003 2.1858923215307851e-07 0.0039200000000000007 -3.3511668231739791e-06 0.0039300000000000003 1.2686140033177463e-07 0.0039399999999999999 4.1146201418527856e-06 0.0039500000000000004 -6.8441273018905434e-07 0.00396 -4.0892859578331888e-06 0.0039700000000000004 -8.0728402995265095e-06 0.00398 -3.0866132254957009e-06 0.0039900000000000005 2.8900311832732181e-06 0.0040000000000000001 -2.7459112846387549e-06 0.0040100000000000005 -1.9542505132409127e-06 0.0040200000000000001 4.815945717850048e-06 0.0040300000000000006 5.2699409499787859e-06 0.0040400000000000002 6.4084576158565166e-07 0.0040500000000000006 -7.7366969441865462e-06 0.0040600000000000002 -8.8402711394430517e-07 0.0040700000000000007 -1.663011953104777e-06 0.0040800000000000003 -4.7021034491680644e-06 0.0040900000000000008 -5.998628803364873e-06 0.0041000000000000003 8.2756945212596234e-06 0.0041099999999999999 7.3818765394623285e-06 0.0041200000000000004 4.8416630149662325e-07 0.00413 6.1803283983426187e-06 0.0041400000000000005 -6.1860599440501138e-07 0.00415 4.6307554988515721e-06 0.0041600000000000005 -5.4772329079463347e-06 0.0041700000000000001 4.8590836051373383e-06 0.0041800000000000006 -4.4506884514089112e-06 0.0041900000000000001 2.442877327885279e-06 0.0042000000000000006 4.0364694667671275e-06 0.0042100000000000002 5.4465989943325223e-06 0.0042200000000000007 -1.2111959979622891e-06 0.0042300000000000003 -1.7927734780593316e-06 0.0042400000000000007 -5.3495804835378075e-06 0.0042500000000000003 -9.9431602960659118e-06 0.0042600000000000008 -2.8376842244011064e-06 0.0042700000000000004 -1.6859168629417105e-06 0.00428 -2.6782454803456871e-06 0.0042900000000000004 2.3453183879596292e-06 0.0043 8.0694318751327731e-06 0.0043100000000000005 -1.5049927399301229e-07 0.0043200000000000001 2.6413603606928192e-06 0.0043300000000000005 4.5704431946257674e-08 0.0043400000000000001 3.6065184385944463e-06 0.0043500000000000006 6.8011778648668039e-06 0.0043600000000000002 1.4979958125158112e-06 0.0043700000000000006 -1.2599778536867818e-06 0.0043800000000000002 3.4655754169301943e-06 0.0043900000000000007 2.9506787143250439e-06 0.0044000000000000003 6.5105317505542466e-06 0.0044100000000000007 -2.4858184313178631e-06 0.0044200000000000003 -1.8439778317275117e-06 0.0044300000000000008 -2.4939895736501964e-06 0.0044400000000000004 1.3312618098004183e-07 0.00445 2.7108189601885827e-06 0.0044600000000000004 2.8571093473865565e-06 0.00447 -4.6455264726297369e-06 0.0044800000000000005 -3.4133564741800234e-06 0.0044900000000000001 2.0792689436635214e-06 0.0045000000000000005 2.344439933328068e-06 0.0045100000000000001 -3.4873973173597643e-06 0.0045200000000000006 -4.3319373051914195e-07 0.0045300000000000002 -1.7700839345938158e-06 0.0045400000000000006 -8.1688304065979333e-06 0.0045500000000000002 9.4932848848132414e-06 0.0045600000000000007 -5.0513861507814052e-06 0.0045700000000000003 -6.3687419077377684e-07 0.0045800000000000007 -2.4103198602967086e-07 0.0045900000000000003 -9.4519750454387786e-07 0.0046000000000000008 -2.4876556592729391e-06 0.0046100000000000004 -1.6867209082613958e-06 0.00462 -1.5466777817057145e-07 0.0046300000000000004 2.8821546062824461e-06 0.00464 1.6361054311447919e-05 0.0046500000000000005 -4.2635005464531228e-06 0.0046600000000000001 1.0455431056565178e-06 0.0046700000000000005 -1.0829604564864993e-05 0.0046800000000000001 -3.0856669428574791e-06 0.0046900000000000006 5.6105186533103305e-06 0.0047000000000000002 -1.0284189955693602e-05 0.0047100000000000006 3.2933411076371509e-06 0.0047200000000000002 1.2859295821964262e-05 0.0047300000000000007 2.1576654096123234e-07 0.0047400000000000003 -3.0739539982455565e-06 0.0047500000000000007 3.3175092434634822e-06 0.0047600000000000003 8.2491293805457355e-07 0.0047700000000000008 7.352114293087155e-06 0.0047800000000000004 -1.1149899926188912e-05 0.00479 9.8228927350615391e-07 0.0048000000000000004 -1.6877783492560941e-06 0.00481 -5.3428923685928167e-06 0.0048200000000000005 -6.0624820690794272e-06 0.0048300000000000001 -1.0499388940846473e-05 0.0048400000000000006 9.1886084659049608e-06 0.0048500000000000001 -4.4803791454052819e-06 0.0048600000000000006 5.0649835123594716e-06 0.0048700000000000002 1.3303315108569396e-06 0.0048800000000000007 -9.8903404143307366e-07 0.0048900000000000002 -1.1599190027535181e-05 0.0049000000000000007 -7.0075004127103918e-06 0.0049100000000000003 7.3003539342426898e-06 0.0049200000000000008 -4.2547267431786031e-06 0.0049300000000000004 2.4472819543320664e-06 0.0049400000000000008 8.2177516273745481e-06 0.0049500000000000004 -9.5425177727362455e-06 0.00496 7.9458610720727286e-06 0.0049700000000000005 -3.2855495405534592e-06 0.0049800000000000001 5.9145957247548106e-07 0.0049900000000000005 -3.8474276513710142e-06 0.0050000000000000001 5.3173824686452736e-06 0.0050100000000000006 -3.3953708881208076e-06 0.0050200000000000002 -5.8649527867659387e-07 0.0050300000000000006 4.5268446280957487e-06 0.0050400000000000002 -9.7691196220692259e-06 0.0050500000000000007 -1.0398542798874857e-05 0.0050600000000000003 8.5375624678887524e-06 0.0050700000000000007 -9.2646556044578441e-06 0.0050800000000000003 -9.5373579343963814e-06 0.0050900000000000008 -4.0092500149915605e-06 0.0051000000000000004 7.9037368615879092e-08 0.0051100000000000008 1.9630979120263736e-06 0.0051200000000000004 -4.762482507363908e-07 0.00513 4.5772448901567173e-07 0.0051400000000000005 -1.311247524333013e-05 0.0051500000000000001 -9.4496570396937861e-06 0.0051600000000000005 2.8225931358622127e-06 0.0051700000000000001 2.4386219234242147e-06 0.0051800000000000006 5.421431128847834e-06 0.0051900000000000002 -4.7311551429756539e-06 0.0052000000000000006 -6.6771455419844479e-06 0.0052100000000000002 -8.1048505487221437e-06 0.0052200000000000007 7.0242077976325952e-07 0.0052300000000000003 4.6828939323860709e-06 0.0052400000000000007 -4.134881982155877e-06 0.0052500000000000003 -1.212938992621184e-06 0.0052600000000000008 4.8012827416075916e-07 0.0052700000000000004 1.5310469348360752e-07 0.0052800000000000008 -6.395912009370886e-06 0.0052900000000000004 4.6120252852479084e-07 0.0053 -6.681390345116802e-08 0.0053100000000000005 1.3819990872859745e-06 0.0053200000000000001 4.6657960430109754e-06 0.0053300000000000005 -3.5276266628790561e-06 0.0053400000000000001 -5.2209171202373951e-06 0.0053500000000000006 1.5112450442832421e-06 0.0053600000000000002 3.5306581805760674e-06 0.0053700000000000006 -1.9692783052042588e-07 0.0053800000000000002 2.3160973773590745e-06 0.0053900000000000007 -7.7134122597495947e-06 0.0054000000000000003 -1.1868427160414665e-06 0.0054100000000000007 4.9431743411533193e-06 0.0054200000000000003 2.9429373531905596e-06 0.0054300000000000008 2.6187788797548025e-06 0.0054400000000000004 -6.9444372365475373e-06 0.0054500000000000009 6.7602850744374918e-06 0.0054600000000000004 9.0167699000121696e-06 0.00547 -1.0714521118266912e-05 0.0054800000000000005 -4.1242006183211976e-07 0.0054900000000000001 -5.4090939311595451e-06 0.0055000000000000005 -2.7597518247041088e-06 0.0055100000000000001 -1.9519559148885105e-06 0.0055200000000000006 -6.2083885354414763e-06 0.0055300000000000002 8.9094832924152593e-07 0.0055400000000000007 7.6111849178954412e-06 0.0055500000000000002 3.081660225015201e-06 0.0055600000000000007 -3.1928387762403407e-07 0.0055700000000000003 3.4269424426144298e-06 0.0055800000000000008 -1.2624647957564456e-06 0.0055900000000000004 2.4865914378474571e-07 0.0056000000000000008 -5.3862506857346149e-06 0.0056100000000000004 9.7775993531955527e-07 0.0056200000000000009 -3.0964999053234229e-06 0.0056300000000000005 -7.2193098516897685e-06 0.00564 -3.5986029473763674e-07 0.0056500000000000005 -6.5190457833382782e-06 0.0056600000000000001 4.0589768908734606e-06 0.0056700000000000006 2.4149974620430738e-06 0.0056800000000000002 4.9805198220049637e-06 0.0056900000000000006 2.102482690912882e-06 0.0057000000000000002 4.4433818106942599e-06 0.0057100000000000007 -5.0269637785310507e-06 0.0057200000000000003 5.927328177318498e-07 0.0057300000000000007 7.5156937726987401e-06 0.0057400000000000003 -2.9529829466919862e-06 0.0057500000000000008 6.3076552242590006e-06 0.0057600000000000004 9.3054652710707179e-06 0.0057700000000000008 2.0158566214682497e-06 0.0057800000000000004 2.3687467871239492e-06 0.0057900000000000009 3.2929116017833351e-06 0.0058000000000000005 -6.2962613914611556e-06 0.0058100000000000001 -2.2701551203167896e-07 0.0058200000000000005 5.7350121719925392e-06 0.0058300000000000001 4.1143552931121254e-06 0.0058400000000000006 7.6582767289474744e-06 0.0058500000000000002 1.6698007144514948e-05 0.0058600000000000006 3.1241433422957972e-06 0.0058700000000000002 2.5544604789423617e-06 0.0058800000000000007 2.3687080306322131e-06 0.0058900000000000003 -4.7199330814804281e-06 0.0059000000000000007 -1.2752634303805766e-06 0.0059100000000000003 -2.7273719676419303e-06 0.0059200000000000008 8.7355325101930814e-07 0.0059300000000000004 -8.0231643862470284e-07 0.0059400000000000008 -3.6962808690339224e-06 0.0059500000000000004 -1.8022370902305608e-06 0.0059600000000000009 3.7649510837124763e-06 0.0059700000000000005 -9.1829974170918271e-06 0.0059800000000000001 -5.8334398184030906e-07 0.0059900000000000005 -4.8067506162172333e-06 0.0060000000000000001 -1.45744039191481e-05 0.0060100000000000006 -2.649918963935268e-06 0.0060200000000000002 7.1660780042934911e-06 0.0060300000000000006 3.0637550767076104e-06 0.0060400000000000002 -4.2306581553532296e-06 0.0060500000000000007 1.6018693677143673e-06 0.0060600000000000003 3.302078374144745e-06 0.0060700000000000007 -2.8755729816161472e-06 0.0060800000000000003 1.8585352664889111e-06 0.0060900000000000008 9.8094256464036253e-06 0.0061000000000000004 2.3350805770485084e-06 0.0061100000000000008 -1.6185259553715917e-06 0.0061200000000000004 8.127773003352624e-06 0.0061300000000000009 -9.7915976079047623e-08 0.0061400000000000005 -3.4472537419584761e-07 0.0061500000000000001 -1.2501854890445077e-05 0.0061600000000000005 -2.9656462566599603e-06 0.0061700000000000001 -8.9450854253282592e-06 0.0061800000000000006 6.55897565063093e-06 0.0061900000000000002 -1.0823795122702298e-05 0.0062000000000000006 -3.8155304750566841e-06 0.0062100000000000002 1.7439322049075116e-06 0.0062200000000000007 8.7704813639721753e-07 0.0062300000000000003 -6.6415157997544464e-06 0.0062400000000000008 -1.6590533630152278e-06 0.0062500000000000003 -3.673701184075096e-06 0.0062600000000000008 -1.4421778175738491e-05 0.0062700000000000004 -5.6939920088842904e-06 0.0062800000000000009 -1.1763565578196786e-07 0.0062900000000000005 1.6426807625342148e-06 0.0063000000000000009 -8.5544388455110446e-07 0.0063100000000000005 4.0756731711579259e-06 0.0063200000000000001 -3.1048465227267334e-06 0.0063300000000000006 3.7572272562502499e-06 0.0063400000000000001 9.3025894932903447e-06 0.0063500000000000006 5.6085553558687567e-06 0.0063600000000000002 -1.0428005303196518e-06 0.0063700000000000007 7.8888552060006136e-06 0.0063800000000000003 8.6306992419297645e-07 0.0063900000000000007 6.0609576491938326e-06 0.0064000000000000003 1.0706090892096301e-05 0.0064100000000000008 -1.2075669758264459e-06 0.0064200000000000004 -7.5984510394883392e-06 0.0064300000000000008 2.3453863315041774e-06 0.0064400000000000004 1.5241225247187514e-06 0.0064500000000000009 5.5510065525850456e-06 0.0064600000000000005 -2.7429941148359905e-06 0.0064700000000000009 -8.9209559521390617e-06 0.0064800000000000005 -5.6529406491193036e-07 0.0064900000000000001 4.8344640617555847e-06 0.0065000000000000006 -6.763628563594199e-06 0.0065100000000000002 -6.3053725270471126e-06 0.0065200000000000006 2.0588969295245151e-06 0.0065300000000000002 1.0003215044871634e-06 0.0065400000000000007 7.1038723431480292e-06 0.0065500000000000003 4.1820972011552982e-07 0.0065600000000000007 -1.3112645772241306e-06 0.0065700000000000003 1.7938673954336884e-06 0.0065800000000000008 -4.8263363285360545e-06 0.0065900000000000004 1.118191284588236e-05 0.0066000000000000008 1.3813177747977312e-05 0.0066100000000000004 -9.2112906369268335e-07 0.0066200000000000009 5.0690600627643664e-06 0.0066300000000000005 -2.7661644631034166e-06 0.0066400000000000009 4.7507408812361973e-06 0.0066500000000000005 4.1605078952722251e-06 0.0066600000000000001 -5.8809918706056993e-06 0.0066700000000000006 5.5330188433919764e-06 0.0066800000000000002 1.9698323301913104e-06 0.0066900000000000006 2.9631420900205427e-06 0.0067000000000000002 -5.7874168989068715e-06 0.0067100000000000007 2.2601572776900196e-06 0.0067200000000000003 -9.9566080069689982e-06 0.0067300000000000007 -3.2343385460581277e-07 0.0067400000000000003 2.5975762241059601e-06 0.0067500000000000008 3.3788114186068854e-06 0.0067600000000000004 -5.406620661420836e-06 0.0067700000000000008 5.6612402445091134e-06 0.0067800000000000004 -2.350520752975921e-07 0.0067900000000000009 -3.988583188585923e-06 0.0068000000000000005 -2.0290598220721565e-06 0.0068100000000000009 -8.1943632624346403e-06 0.0068200000000000005 -6.3815731648950628e-06 0.0068300000000000001 3.6215697811083687e-06 0.0068400000000000006 7.9817688937891697e-07 0.0068500000000000002 7.5549732951001361e-06 0.0068600000000000006 -1.4738609197511254e-05 0.0068700000000000002 -2.5855599789579326e-06 0.0068800000000000007 -4.2728094519869362e-06 0.0068900000000000003 -5.3690413178859376e-06 0.0069000000000000008 -6.4242752904471127e-06 0.0069100000000000003 4.3413738644886805e-07 0.0069200000000000008 -6.9837983274587144e-06 0.0069300000000000004 5.2206535299524777e-06 0.0069400000000000009 5.2581062234875894e-06 0.0069500000000000004 2.6663149210357152e-06 0.0069600000000000009 -9.066927015775752e-08 0.0069700000000000005 6.7878766335102414e-08 0.006980000000000001 -9.1600150636788491e-06 0.0069900000000000006 -2.9484449606670317e-06 0.0070000000000000001 9.8990114656390186e-06 0.0070100000000000006 -1.0128174268104466e-05 0.0070200000000000002 -5.4501831230308166e-06 0.0070300000000000007 2.1936351223049261e-06 0.0070400000000000003 -8.4824024282172294e-06 0.0070500000000000007 1.6259427913039263e-06 0.0070600000000000003 1.3835621560427581e-06 0.0070700000000000008 3.0302633176263828e-06 0.0070800000000000004 -2.6628750758384853e-07 0.0070900000000000008 5.6325474108058253e-06 0.0071000000000000004 2.4721872694195038e-06 0.0071100000000000009 -1.4066311052652813e-06 0.0071200000000000005 -3.7290548351194505e-06 0.0071300000000000009 1.0060371757384709e-06 0.0071400000000000005 -1.0564605372481348e-06 0.007150000000000001 2.1913172020690129e-06 0.0071600000000000006 1.0634838484258906e-05 0.0071700000000000002 -2.1782283026601865e-06 0.0071800000000000006 -2.7285207321218792e-06 0.0071900000000000002 -2.6989124202839825e-06 0.0072000000000000007 -7.903375563656797e-06 0.0072100000000000003 -8.4222213720449493e-07 0.0072200000000000007 -7.7804078954998846e-06 0.0072300000000000003 -6.9923242618017647e-06 0.0072400000000000008 3.0884677004076129e-06 0.0072500000000000004 -9.0691195536268546e-06 0.0072600000000000008 3.3053148507854882e-06 0.0072700000000000004 7.9637735206475605e-06 0.0072800000000000009 4.7206890876431787e-06 0.0072900000000000005 -1.9603744445444198e-06 0.0073000000000000009 1.5756552840998411e-06 0.0073100000000000005 -7.9344870831912269e-06 0.007320000000000001 -7.9500742879235979e-07 0.0073300000000000006 1.2967082385336285e-06 0.0073400000000000002 -5.8045709437684152e-06 0.0073500000000000006 -8.0618134439586382e-06 0.0073600000000000002 -4.9963469888319656e-06 0.0073700000000000007 -7.7931166216467162e-07 0.0073800000000000003 1.4298594575489998e-06 0.0073900000000000007 -4.9688150176027668e-06 0.0074000000000000003 -5.380539873533788e-06 0.0074100000000000008 -1.8918805323136397e-06 0.0074200000000000004 7.9679431595935424e-07 0.0074300000000000008 -1.4135906225364346e-06 0.0074400000000000004 4.4197167346041472e-06 0.0074500000000000009 -5.0268670036365486e-06 0.0074600000000000005 -8.7839520475131473e-07 0.0074700000000000009 3.1349599606406568e-06 0.0074800000000000005 6.4554629560612085e-06 0.007490000000000001 -6.7728483196384496e-06 0.0075000000000000006 6.9171314197874704e-06 0.0075100000000000002 1.1577299472044863e-07 0.0075200000000000006 -3.868755672859089e-06 0.0075300000000000002 4.1790673736868231e-06 0.0075400000000000007 -4.6060661593727279e-06 0.0075500000000000003 6.4779831842866889e-06 0.0075600000000000007 -3.3946150994105214e-07 0.0075700000000000003 1.2944529672329013e-06 0.0075800000000000008 -2.5536264828174233e-06 0.0075900000000000004 2.5799016831184736e-06 0.0076000000000000009 -3.6212072054750584e-06 0.0076100000000000004 4.6438449355089605e-06 0.0076200000000000009 -1.207429479435478e-05 0.0076300000000000005 -5.3243189015872054e-06 0.007640000000000001 -9.74275492465628e-06 0.0076500000000000005 1.5680563636712324e-06 0.007660000000000001 1.0084374386968843e-06 0.0076700000000000006 -5.7816016812938267e-06 0.0076800000000000011 4.8331578378697461e-06 0.0076900000000000007 1.0774351816634467e-06 0.0077000000000000002 7.881463193163012e-06 0.0077100000000000007 3.1145596983593388e-06 0.0077200000000000003 9.6353069836999994e-06 0.0077300000000000008 -5.2466280733323219e-06 0.0077400000000000004 2.0377610610919737e-06 0.0077500000000000008 -3.8301563252967208e-06 0.0077600000000000004 3.3630938914105137e-06 0.0077700000000000009 1.2966020915848344e-06 0.0077800000000000005 -4.2999359371447786e-06 0.0077900000000000009 9.1071052340481002e-06 0.0078000000000000005 2.2388875235580736e-07 0.007810000000000001 4.915775787114368e-06 0.0078200000000000006 -1.1290989043370458e-05 0.0078300000000000002 3.4104923240147764e-06 0.0078400000000000015 -2.3647741229030957e-06 0.0078500000000000011 -1.6411501010877419e-07 0.0078600000000000007 -7.3311170299859521e-06 0.0078700000000000003 7.9429040170303656e-06 0.0078799999999999999 5.2918806515943379e-06 0.0078900000000000012 1.1047049533362387e-06 0.0079000000000000008 -6.1704385558966458e-06 0.0079100000000000004 1.5290649543723333e-06 0.00792 3.1706759069682667e-06 0.0079300000000000013 1.9689950061545759e-06 0.0079400000000000009 -3.6471156411495031e-06 0.0079500000000000005 -1.3824439695797143e-06 0.0079600000000000001 -1.3523078825619043e-06 0.0079700000000000014 -2.5484098181484127e-06 0.007980000000000001 -5.7887414243732091e-06 0.0079900000000000006 2.615608785242337e-07 0.0080000000000000002 3.5959731823283155e-07 0.0080100000000000015 -1.1997255433659851e-06 0.0080200000000000011 -5.7997766411873944e-06 0.0080300000000000007 2.8412926658220495e-06 0.0080400000000000003 1.0496490357626963e-05 0.0080499999999999999 -9.7066454511917024e-06 0.0080600000000000012 -6.0286199245627467e-06 0.0080700000000000008 6.2655292726332383e-06 0.0080800000000000004 -3.7078228286889051e-06 0.00809 -7.6270240339723399e-06 0.0081000000000000013 -2.2427433307364473e-06 0.0081100000000000009 5.9007183975473059e-06 0.0081200000000000005 -4.8386867318626304e-06 0.0081300000000000001 3.1996734328067974e-06 0.0081400000000000014 3.45399740543532e-06 0.008150000000000001 9.1454577292811051e-06 0.0081600000000000006 2.7090556950386331e-06 0.0081700000000000002 -9.8389061157726289e-06 0.0081800000000000015 8.7799975620843069e-06 0.0081900000000000011 3.4295971723751357e-06 0.0082000000000000007 1.0232525097421909e-05 0.0082100000000000003 1.3039963405829192e-06 0.0082199999999999999 -7.549864178879109e-06 0.0082300000000000012 7.9126810139047618e-06 0.0082400000000000008 4.664320548329225e-07 0.0082500000000000004 -1.002089817284809e-05 0.00826 -7.8266270916253999e-07 0.0082700000000000013 -3.2771127385790853e-06 0.0082800000000000009 1.2804502422703454e-06 0.0082900000000000005 -2.7560491664006527e-06 0.0083000000000000001 -5.7391060086534931e-06 0.0083100000000000014 -1.3972999713238505e-06 0.008320000000000001 -2.8996581041468493e-07 0.0083300000000000006 -1.9495157528472029e-06 0.0083400000000000002 -3.7714070015414009e-07 0.0083500000000000015 -1.7558423737442428e-07 0.0083600000000000011 1.0522874235745662e-06 0.0083700000000000007 -7.2227944076118147e-06 0.0083800000000000003 -3.9334933840133834e-06 0.0083899999999999999 2.6378436179657384e-06 0.0084000000000000012 5.1027611761400521e-06 0.0084100000000000008 1.8460710013105042e-06 0.0084200000000000004 -1.2865826735217266e-06 0.00843 4.0154555503234885e-08 0.0084400000000000013 -9.2774639039211396e-06 0.0084500000000000009 -2.8719715478657337e-06 0.0084600000000000005 7.2197519553015719e-06 0.0084700000000000001 1.4379193093211715e-06 0.0084800000000000014 -2.779922577824354e-06 0.008490000000000001 8.1918555271569963e-06 0.0085000000000000006 4.7578761569494554e-06 0.0085100000000000002 -7.4376892840615317e-07 0.0085200000000000015 -1.1194550814327862e-06 0.0085300000000000011 1.9710567449758068e-06 0.0085400000000000007 -1.6134907974558719e-06 0.0085500000000000003 -6.6298706884863992e-07 0.0085599999999999999 -3.3150784987070726e-06 0.0085700000000000012 -5.3796037215718899e-07 0.0085800000000000008 -1.0241444397013295e-06 0.0085900000000000004 -9.232847342861828e-07 0.0086 9.6315067002792026e-06 0.0086100000000000013 9.379568221966151e-06 0.0086200000000000009 -3.0464000675133364e-06 0.0086300000000000005 4.2339893033306913e-06 0.0086400000000000001 -5.8651841845246992e-06 0.0086500000000000014 -9.823554444342816e-06 0.008660000000000001 1.1146912775789566e-05 0.0086700000000000006 3.4531286884915619e-06 0.0086800000000000002 -8.2219762525811773e-07 0.0086900000000000015 2.8052781070483986e-06 0.0087000000000000011 -2.6603838668139399e-06 0.0087100000000000007 -2.0043060259080576e-06 0.0087200000000000003 6.7244234228310071e-06 0.0087299999999999999 1.2053486465225136e-06 0.0087400000000000012 8.6198562707897517e-06 0.0087500000000000008 -1.2759920280924499e-06 0.0087600000000000004 -5.1417401734555066e-07 0.00877 2.768852078002759e-07 0.0087800000000000013 -9.739388206735278e-06 0.0087900000000000009 7.6385614974260292e-06 0.0088000000000000005 -1.8680787212768175e-06 0.0088100000000000001 -4.6277059107874165e-06 0.0088200000000000014 5.8180731156383361e-06 0.008830000000000001 -7.6164105340833285e-06 0.0088400000000000006 7.2110139628315446e-06 0.0088500000000000002 -7.597825334802358e-06 0.0088600000000000016 6.5918796813625375e-06 0.0088700000000000011 1.9805199258533333e-06 0.0088800000000000007 -9.5317705091496627e-07 0.0088900000000000003 2.4042076474065331e-06 0.0088999999999999999 -4.2798102238475272e-06 0.0089100000000000013 -1.8272748933061238e-06 0.0089200000000000008 -6.3484760692356073e-07 0.0089300000000000004 -3.9124506889690075e-06 0.00894 -5.0804319267474681e-06 0.0089500000000000014 4.5316840944360986e-06 0.0089600000000000009 -7.1081184436988401e-06 0.0089700000000000005 -7.5587433639853356e-06 0.0089800000000000001 2.2327267704597184e-06 0.0089900000000000015 -8.7332006407510864e-06 0.0090000000000000011 -5.0108595780431058e-06 0.0090100000000000006 4.226486567977998e-06 0.0090200000000000002 8.6846843615174562e-07 0.0090300000000000016 2.7008633805768692e-06 0.0090400000000000012 2.4572204452300723e-06 0.0090500000000000008 -1.2428797195533508e-06 0.0090600000000000003 -4.6494538505321249e-06 0.0090699999999999999 4.3151149560225811e-06 0.0090800000000000013 4.6590918044654966e-06 0.0090900000000000009 -5.8848845976052983e-06 0.0091000000000000004 2.3985759682199337e-06 0.00911 8.458218845178781e-06 0.0091200000000000014 5.1323758170305002e-07 0.009130000000000001 -8.3941809210613775e-06 0.0091400000000000006 -4.0579634435043204e-06 0.0091500000000000001 -9.4797612968305773e-06 0.0091600000000000015 6.8377781147206531e-06 0.0091700000000000011 -3.2097276903868885e-07 0.0091800000000000007 6.2424130607682564e-06 0.0091900000000000003 -4.4829852487516384e-06 0.0092000000000000016 9.8628153233348961e-06 0.0092100000000000012 5.7742532017843931e-06 0.0092200000000000008 -2.8080261927339259e-06 0.0092300000000000004 -5.0167537809749735e-06 0.0092399999999999999 -4.1930180966635867e-06 0.0092500000000000013 1.3129276022320018e-06 0.0092600000000000009 5.7773202668083133e-07 0.0092700000000000005 2.2245892337049301e-06 0.0092800000000000001 -7.3024599207710645e-06 0.0092900000000000014 -4.5055995406667938e-06 0.009300000000000001 -5.3658180881196831e-06 0.0093100000000000006 5.3980881058739597e-06 0.0093200000000000002 5.2925004390684258e-07 0.0093300000000000015 -4.7637278018734038e-06 0.0093400000000000011 -8.5166613992647422e-06 0.0093500000000000007 7.0531271860303649e-06 0.0093600000000000003 -8.4135811551741302e-06 0.0093700000000000016 -2.4684296899353285e-06 0.0093800000000000012 -2.3207936732915793e-06 0.0093900000000000008 -3.9022490886347799e-06 0.0094000000000000004 1.1218376406062923e-05 0.00941 -1.9224784536882078e-06 0.0094200000000000013 -1.9646821842813214e-06 0.0094300000000000009 8.3032769115075078e-06 0.0094400000000000005 3.7176315198335523e-06 0.0094500000000000001 1.2638564106621854e-05 0.0094600000000000014 -1.1744768671471156e-06 0.009470000000000001 2.3371589094163033e-06 0.0094800000000000006 -2.5963861017991427e-06 0.0094900000000000002 -5.8662979461907213e-06 0.0095000000000000015 1.552245149518704e-06 0.0095100000000000011 -2.3642645487822341e-07 0.0095200000000000007 -4.6223582197888098e-06 0.0095300000000000003 1.4001198385163478e-05 0.0095400000000000016 3.1556274354805002e-06 0.0095500000000000012 -3.307250861896991e-06 0.0095600000000000008 -3.2114842613355699e-06 0.0095700000000000004 3.9297424985280611e-06 0.00958 -4.2026285687505742e-07 0.0095900000000000013 2.0576896346658057e-06 0.0096000000000000009 5.8735566846995899e-06 0.0096100000000000005 1.1396359160838303e-05 0.0096200000000000001 -1.8795624083730119e-06 0.0096300000000000014 1.7245749770747617e-07 0.009640000000000001 6.7327916414096495e-06 0.0096500000000000006 -9.0647187815737217e-06 0.0096600000000000002 -1.8524895865847176e-06 0.0096700000000000015 7.7201591833394096e-07 0.0096800000000000011 -8.1081638191864858e-07 0.0096900000000000007 3.4634135630667215e-06 0.0097000000000000003 2.9887684187150268e-06 0.0097100000000000016 1.7899237958567023e-06 0.0097200000000000012 -2.5464231350304818e-06 0.0097300000000000008 5.8511219123667903e-06 0.0097400000000000004 -7.3618305985123285e-06 0.00975 4.1528654467573312e-06 0.0097600000000000013 -3.7349498158685793e-06 0.0097700000000000009 6.9694133929639804e-08 0.0097800000000000005 3.5421862204646579e-06 0.0097900000000000001 2.0937669359697083e-07 0.0098000000000000014 9.4008679799985394e-08 0.009810000000000001 -7.5632188128050996e-06 0.0098200000000000006 -1.0163243104986112e-06 0.0098300000000000002 3.0242705267067444e-06 0.0098400000000000015 5.598536389859118e-06 0.0098500000000000011 2.0008127985164813e-06 0.0098600000000000007 2.0514193293231101e-06 0.0098700000000000003 -3.9964658778641959e-06 0.0098800000000000016 -6.9822817022330916e-06 0.0098900000000000012 3.9676039438117532e-07 0.0099000000000000008 -1.7698441581585754e-06 0.0099100000000000004 -3.4387513030828179e-06 0.00992 3.3789681375424887e-06 0.0099300000000000013 -7.0841533533289052e-07 0.0099400000000000009 8.5948551277472542e-06 0.0099500000000000005 9.2178084739471402e-06 0.0099600000000000001 -7.728650404906229e-06 0.0099700000000000014 -5.2784208034400839e-06 0.009980000000000001 -5.7647034539091838e-06 0.0099900000000000006 -1.2926389256248539e-05 0.01 2.7049653968724958e-06 0.010010000000000002 -5.6506862816038772e-07 0.010020000000000001 6.4556494216208558e-06 0.010030000000000001 -2.5857543701624653e-06 0.01004 -6.4679326791950802e-06 0.010050000000000002 2.7305308705428811e-06 0.010060000000000001 5.1678107754087947e-06 0.010070000000000001 -1.5817111261209541e-06 0.01008 4.9801409992510444e-07 0.01009 -2.3842539190347e-06 0.010100000000000001 9.4710823829257823e-07 0.010110000000000001 3.5403367962018847e-06 0.010120000000000001 9.1243278248458065e-08 0.01013 -1.9324378427440386e-06 0.010140000000000001 -7.5233413927081998e-06 0.010150000000000001 -9.773287892988331e-07 0.010160000000000001 -1.223813895241078e-06 0.01017 -2.4183408261806148e-06 0.010180000000000002 -1.3755623077440564e-06 0.010190000000000001 -7.0598410945762237e-06 0.010200000000000001 -4.1132217435741973e-06 0.01021 2.0815763403140907e-06 0.010220000000000002 -5.1937745534922376e-07 0.010230000000000001 1.1414213843796237e-06 0.010240000000000001 -9.1349621633845293e-07 0.01025 5.6618110996567246e-07 0.01026 4.543791702653614e-06 0.010270000000000001 1.1077336029059789e-06 0.010280000000000001 1.8338085704520484e-06 0.010290000000000001 -2.8718191372127184e-06 0.0103 -2.4847764976209409e-06 0.010310000000000001 -5.7614219616803656e-06 0.010320000000000001 1.0894747127306009e-05 0.010330000000000001 1.1023046599375032e-05 0.01034 -2.393476410381614e-06 0.010350000000000002 -8.4141932204582637e-06 0.010360000000000001 3.0343894223514019e-06 0.010370000000000001 9.354490700553592e-07 0.01038 -2.2677275080999509e-06 0.010390000000000002 3.0884299080147075e-06 0.010400000000000001 -1.8630271869914266e-06 0.010410000000000001 -3.672978201567849e-06 0.01042 -3.9796326576083951e-06 0.01043 4.7699604457961716e-06 0.010440000000000001 2.0952992345497249e-06 0.010450000000000001 4.563596525958044e-06 0.010460000000000001 -3.8816289094168444e-06 0.01047 -9.7347365809059562e-06 0.010480000000000001 6.1184359800594943e-07 0.010490000000000001 -6.1147651706735834e-06 0.010500000000000001 -2.0532904511900633e-06 0.01051 -5.3686050153657763e-09 0.010520000000000002 9.5384211300586268e-06 0.010530000000000001 5.9447395134038074e-06 0.010540000000000001 -1.6550424578952473e-06 0.01055 -1.9553805381786984e-06 0.010560000000000002 1.3907350944181517e-06 0.010570000000000001 4.5572129309264222e-06 0.010580000000000001 -1.4624805784021789e-06 0.01059 -1.3076397750526037e-05 0.0106 -4.0510387769728904e-07 0.010610000000000001 -7.1817299567075612e-07 0.010620000000000001 1.8426251176035229e-06 0.010630000000000001 -5.7466874857759345e-06 0.01064 -1.7659680599458281e-06 0.010650000000000001 -5.1148575412810311e-06 0.010660000000000001 -1.1089219217808904e-05 0.010670000000000001 7.1649004905169302e-08 0.01068 5.0794531374195574e-06 0.010690000000000002 -3.9020761244172888e-06 0.010700000000000001 -1.310454261106249e-06 0.010710000000000001 -1.7703458704466483e-06 0.01072 -3.3690814974799985e-06 0.010730000000000002 -4.5911433227284348e-07 0.010740000000000001 -3.4142484567225796e-07 0.010750000000000001 7.9784664438489189e-07 0.01076 -2.0138717972200697e-06 0.01077 -7.6643727597323758e-06 0.010780000000000001 -3.5244426109826847e-06 0.010790000000000001 6.9007942145516061e-06 0.010800000000000001 1.5515268488498915e-06 0.01081 1.0637873418084222e-06 0.010820000000000001 -6.2929747917769398e-07 0.010830000000000001 -1.2955468774267144e-05 0.010840000000000001 5.623364284898983e-06 0.01085 -4.1359613951431728e-06 0.010860000000000002 3.9746036980724955e-06 0.010870000000000001 -6.2120732749843036e-06 0.010880000000000001 8.6169221334790128e-07 0.01089 1.4487066738492168e-06 0.010900000000000002 1.8129861108974118e-06 0.010910000000000001 7.1561468870876208e-06 0.010920000000000001 3.1808104008878177e-06 0.01093 5.8574893987578871e-06 0.01094 -6.0929752604771408e-06 0.010950000000000001 -3.7078541251401543e-06 0.010960000000000001 4.4839355250024195e-06 0.010970000000000001 4.5809093912004871e-06 0.01098 1.0417396649498634e-06 0.010990000000000002 2.635483786518741e-06 0.011000000000000001 -3.6068605143071323e-06 0.011010000000000001 8.7785160001588332e-07 0.01102 3.1654228656326053e-06 0.011030000000000002 9.0085648894192504e-06 0.011040000000000001 -4.0093364248610592e-07 0.011050000000000001 -7.8183035311155746e-06 0.01106 -2.917092427877252e-07 0.011070000000000002 2.3441719814827688e-06 0.011080000000000001 3.1250939237760203e-06 0.011090000000000001 6.7792388925103605e-06 0.0111 -3.5461554752983284e-06 0.01111 6.4287427896792256e-06 0.011120000000000001 -7.7426786923150655e-07 0.011130000000000001 -5.2309294369279261e-06 0.011140000000000001 -4.8784864841872786e-06 0.01115 -4.958448324770131e-06 0.011160000000000002 -2.8644825964321738e-06 0.011170000000000001 7.794349689369059e-08 0.011180000000000001 -4.5271419095722111e-06 0.01119 -1.1465501796771201e-05 0.011200000000000002 -8.5606510078598578e-06 0.011210000000000001 -2.7988114509938526e-06 0.011220000000000001 -1.3497949482302091e-07 0.01123 1.797838596973689e-08 0.011240000000000002 6.9920124045903549e-07 0.011250000000000001 -2.2447708956882063e-06 0.011260000000000001 -3.0995162264500535e-06 0.011270000000000001 -3.9290602352399679e-06 0.01128 2.9365209429099473e-06 0.011290000000000001 1.4104054920235493e-06 0.011300000000000001 -1.079543770312239e-06 0.011310000000000001 8.6659091872487819e-06 0.01132 -8.3985437841012269e-06 0.011330000000000002 -2.0337042926102521e-06 0.011340000000000001 -4.6154721814183156e-06 0.011350000000000001 1.5300309751637992e-06 0.01136 7.8774943988518506e-06 0.011370000000000002 8.6623411327266583e-06 0.011380000000000001 -6.26182973941274e-06 0.011390000000000001 -5.1522072124063428e-06 0.0114 -2.1210106306978776e-06 0.011410000000000002 5.3082045552316804e-06 0.011420000000000001 -5.5559537234669292e-06 0.011430000000000001 6.4535734754562814e-06 0.011440000000000001 -4.0559133244223509e-07 0.01145 -3.336898166323576e-06 0.011460000000000001 -1.1790745708025749e-06 0.011470000000000001 1.6938256382643359e-06 0.011480000000000001 1.0331738093319699e-06 0.01149 -2.7328491890575613e-06 0.011500000000000002 2.8526696551701943e-06 0.011510000000000001 -1.7084638537941355e-05 0.011520000000000001 9.5548312010206299e-07 0.01153 1.4187993775427339e-06 0.011540000000000002 5.2006263693776582e-06 0.011550000000000001 -1.0690057459103726e-05 0.011560000000000001 4.1112630765076864e-06 0.01157 -2.5935748001816141e-06 0.011580000000000002 -9.2927049503224787e-07 0.011590000000000001 -4.214815229555679e-06 0.011600000000000001 -2.7296872740887408e-06 0.011610000000000001 -4.6303076376998432e-06 0.01162 4.8025426899542634e-06 0.011630000000000001 -6.3517526216189004e-07 0.011640000000000001 4.5864914779009986e-06 0.011650000000000001 2.6563008042377188e-06 0.01166 6.0130906719713763e-06 0.011670000000000002 -6.0019281340515833e-06 0.011680000000000001 3.5816168026976963e-06 0.011690000000000001 2.7195851386569129e-06 0.0117 3.1937156704364298e-06 0.011710000000000002 7.5868108837866041e-07 0.011720000000000001 -3.4143401073648476e-06 0.011730000000000001 9.9323747052198961e-07 0.01174 3.9657706907751592e-06 0.011750000000000002 5.5695965416177844e-06 0.011760000000000001 -3.6956189574373154e-06 0.011770000000000001 -4.6767401563923423e-06 0.011780000000000001 3.4378422791147616e-06 0.01179 2.5860728217875679e-06 0.011800000000000001 -5.8118356400188606e-06 0.011810000000000001 1.4101147982792307e-06 0.011820000000000001 1.798917633944933e-06 0.01183 -4.2398934420124814e-06 0.011840000000000002 -1.2651305006697132e-06 0.011850000000000001 1.4297281542462843e-06 0.011860000000000001 8.0544519268338082e-06 0.01187 5.9350919062241283e-07 0.011880000000000002 1.163702900734315e-05 0.011890000000000001 -8.5250210043532971e-07 0.011900000000000001 -9.9439660364446873e-06 0.01191 -4.1072584072960207e-07 0.011920000000000002 4.6938246614432772e-06 0.011930000000000001 -7.1417065843404877e-06 0.011940000000000001 -1.8153139539792795e-06 0.011950000000000001 9.0006693828698842e-07 0.01196 -3.7499219439752555e-06 0.011970000000000001 1.9594788690402404e-06 0.011980000000000001 4.0303386160801169e-07 0.011990000000000001 -3.4905095410575352e-06 0.012 4.1197539851752115e-06 0.012010000000000002 -6.8099542128114452e-06 0.012020000000000001 -6.5830844031301525e-06 0.012030000000000001 1.0865415400218389e-06 0.01204 -5.4201385629024424e-06 0.012050000000000002 -1.0812402819671145e-06 0.012060000000000001 1.368059398183257e-06 0.012070000000000001 2.5622609335777778e-06 0.01208 -1.721418305660775e-06 0.012090000000000002 -2.3866745173098562e-06 0.012100000000000001 6.8528675886771645e-06 0.012110000000000001 -1.5930787351078448e-06 0.012120000000000001 -4.1517349766643926e-06 0.01213 -1.9468506582568016e-06 0.012140000000000001 6.5177399821056526e-07 0.012150000000000001 4.3449322859725613e-06 0.012160000000000001 -3.5173919714772965e-06 0.01217 -6.4889927844501223e-07 0.012180000000000002 5.4293658666511859e-06 0.012190000000000001 4.0078456407985729e-06 0.012200000000000001 -3.3349264237839017e-06 0.01221 -8.0943501821417042e-06 0.012220000000000002 9.6284664544947107e-07 0.012230000000000001 -3.1265051755060663e-07 0.012240000000000001 1.1833593507996536e-06 0.01225 4.4488537106926018e-06 0.012260000000000002 2.4895610740401759e-06 0.012270000000000001 4.0744548224675803e-06 0.012280000000000001 4.0123259470827999e-06 0.012290000000000001 -4.7145391705638359e-06 0.0123 5.2568567173061167e-07 0.012310000000000001 8.0631779031003549e-06 0.012320000000000001 -8.1791905279859315e-06 0.012330000000000001 -2.5124937844850712e-06 0.01234 7.7677549576266133e-06 0.012350000000000002 1.0860194824587196e-05 0.012360000000000001 -6.1160546281421975e-07 0.012370000000000001 -3.7083684286568486e-07 0.01238 6.5028482709993233e-06 0.012390000000000002 1.2727501156666582e-06 0.012400000000000001 1.7356446306707193e-06 0.012410000000000001 -8.9815278724052898e-06 0.01242 3.164758873980981e-06 0.012430000000000002 -3.3596910308368889e-06 0.012440000000000001 1.1520740943905038e-05 0.012450000000000001 1.1553828673732391e-06 0.012460000000000001 1.2392924294134424e-06 0.01247 3.40927141504164e-06 0.012480000000000002 -3.7727218744395138e-06 0.012490000000000001 -3.9946710574226241e-06 0.012500000000000001 2.5791072969056953e-06 0.01251 -6.128977261233824e-06 0.012520000000000002 -3.5896650688377897e-06 0.012530000000000001 -1.3045074299747817e-06 0.012540000000000001 -7.6281915886633086e-06 0.01255 -1.0100499213397494e-05 0.012560000000000002 3.8949492580493807e-06 0.012570000000000001 -4.5671152560830289e-06 0.012580000000000001 7.6001107358198296e-07 0.01259 -9.5671916992949188e-07 0.012600000000000002 1.0686095688616553e-05 0.012610000000000001 -6.6606747501566601e-06 0.012620000000000001 1.0615916636975359e-05 0.012630000000000001 4.612243091709824e-06 0.01264 7.3043514758335788e-06 0.012650000000000002 1.0257167594008018e-05 0.012660000000000001 -2.3430954855547681e-06 0.012670000000000001 -5.4264289789980209e-06 0.01268 -4.3137893997747813e-06 0.012690000000000002 9.8809723477120871e-07 0.012700000000000001 -5.9793613000442029e-06 0.012710000000000001 4.3451637325855933e-06 0.01272 1.306945932614139e-06 0.012730000000000002 -8.886982320621322e-07 0.012740000000000001 1.0280166183939439e-05 0.012750000000000001 -4.1945443130077451e-07 0.012760000000000001 -4.918575325150101e-06 0.012770000000000002 -6.9684289037202876e-06 0.012780000000000001 9.4187831157521841e-06 0.012790000000000001 -2.9156177445256116e-06 0.012800000000000001 7.6944544985535431e-07 0.01281 -5.7947803165813358e-06 0.012820000000000002 -2.3143686373705869e-06 0.012830000000000001 -2.4447882097028046e-06 0.012840000000000001 8.9928751506229798e-06 0.01285 -4.7575355102873805e-06 0.012860000000000002 1.9131163364986194e-06 0.012870000000000001 5.4646336753935396e-06 0.012880000000000001 -4.1709215122108657e-06 0.01289 4.8016282305879866e-06 0.012900000000000002 -5.9244744466620685e-07 0.012910000000000001 -2.1048718569743616e-07 0.012920000000000001 -5.6284762612831603e-06 0.012930000000000001 -3.7633041715434636e-06 0.012940000000000002 4.212918275608528e-07 0.012950000000000001 7.9618056978237103e-06 0.012960000000000001 2.4933760139447071e-06 0.012970000000000001 8.6007522563637495e-07 0.01298 -1.9018403965216187e-06 0.012990000000000002 6.6879814688540924e-06 0.013000000000000001 4.5848902361852991e-06 0.013010000000000001 2.3355474354925337e-06 0.01302 -1.3672117246925644e-05 0.013030000000000002 -2.5511571151689231e-06 0.013040000000000001 3.3555031804956502e-06 0.013050000000000001 1.8076707428919211e-07 0.01306 6.231832502596377e-06 0.013070000000000002 6.2234987744799634e-06 0.013080000000000001 -2.0074348959644319e-07 0.013090000000000001 -7.7681474533271977e-07 0.013100000000000001 -2.6937653665184586e-06 0.013110000000000002 2.5788213197875468e-06 0.013120000000000001 6.625206041932977e-06 0.013130000000000001 -3.1467134363697743e-06 0.013140000000000001 -6.0045344134088137e-06 0.01315 -2.1564683414123249e-06 0.013160000000000002 -3.3713799405598944e-06 0.013170000000000001 -5.9992782166712237e-06 0.013180000000000001 2.0332554190424023e-06 0.01319 5.591984777278109e-06 0.013200000000000002 6.9884660655461924e-07 0.013210000000000001 -5.7076701691795787e-06 0.013220000000000001 -5.7346867981354237e-06 0.01323 -1.9084705839166274e-06 0.013240000000000002 1.2779434140683604e-05 0.013250000000000001 -5.6007149000619095e-06 0.013260000000000001 -1.1194877512068126e-06 0.013270000000000001 -4.7382724087637009e-06 0.013280000000000002 4.1555156474217936e-06 0.013290000000000001 1.3680945927569673e-05 0.013300000000000001 7.2116645393174655e-06 0.013310000000000001 3.0494218355527261e-07 0.01332 4.8653799101444702e-06 0.013330000000000002 2.4123466871426897e-06 0.013340000000000001 3.1923534264107423e-06 0.013350000000000001 5.405892363756614e-08 0.01336 -1.0065643047516666e-05 0.013370000000000002 5.9516501792963513e-06 0.013380000000000001 -1.1569258860841834e-06 0.013390000000000001 -7.5099342375178618e-06 0.0134 1.9322470440449896e-06 0.013410000000000002 -6.67844540125591e-06 0.013420000000000001 -4.810417826862648e-07 0.013430000000000001 6.4275425554998148e-06 0.013440000000000001 -6.1365093099655653e-07 0.013450000000000002 3.1504112131266927e-06 0.013460000000000001 -5.6858319337680509e-06 0.013470000000000001 5.085103472416756e-06 0.013480000000000001 3.1247909444045178e-07 0.01349 3.0260689121721849e-06 0.013500000000000002 7.1954021368569838e-06 0.013510000000000001 7.8655023893219314e-06 0.013520000000000001 -6.4148105184694276e-06 0.01353 -7.4308670070272301e-06 0.013540000000000002 1.700506620275056e-07 0.013550000000000001 4.6500635849578111e-06 0.013560000000000001 1.75722085278791e-06 0.01357 1.5467513405819242e-06 0.013580000000000002 -1.8856632127911023e-06 0.013590000000000001 1.4399701966258215e-06 0.013600000000000001 2.7936061845195262e-06 0.013610000000000001 -3.0277681627499562e-06 0.013620000000000002 8.7410669897881113e-06 0.013630000000000001 1.2758757704280817e-06 0.013640000000000001 -6.269758936565047e-06 0.013650000000000001 -4.6336802718396189e-07 0.01366 -8.8097354455529324e-06 0.013670000000000002 -2.852869126452027e-06 0.013680000000000001 5.3305731152610177e-06 0.013690000000000001 -1.0123139326146545e-06 0.0137 8.8619293779251573e-06 0.013710000000000002 3.9764698158460854e-06 0.013720000000000001 -1.3685454784097618e-06 0.013730000000000001 -1.4183185918990622e-06 0.01374 -6.618411884022041e-06 0.013750000000000002 2.1372164134175862e-06 0.013760000000000001 -3.6146501407720822e-06 0.013770000000000001 2.523193398241397e-06 0.013780000000000001 -3.043377992447713e-06 0.013790000000000002 -1.1874386772211466e-06 0.013800000000000002 2.3865545142829231e-06 0.013810000000000001 1.9186076021065987e-06 0.013820000000000001 8.579593514696837e-06 0.01383 3.972673163606021e-06 0.013840000000000002 -2.0996576289320323e-06 0.013850000000000001 -5.5658105376710167e-06 0.013860000000000001 2.8736055786130956e-06 0.01387 -4.1244107189374029e-06 0.013880000000000002 -2.8923287695418587e-06 0.013890000000000001 2.192133048973535e-06 0.013900000000000001 2.8238721276902848e-06 0.01391 -5.1543064681445886e-06 0.013920000000000002 -1.3466667384241868e-07 0.013930000000000001 -5.9904845248074351e-07 0.013940000000000001 2.8972896458509825e-06 0.013950000000000001 -1.3771987989453822e-06 0.013960000000000002 5.3814666603570301e-06 0.013970000000000002 -8.8848135927797813e-06 0.013980000000000001 1.5837764035722866e-06 0.013990000000000001 1.581499367315543e-06 0.014 -4.1137414202133973e-06 0.014010000000000002 7.6932788374703683e-06 0.014020000000000001 3.7155940526437858e-06 0.014030000000000001 -2.0443284836095729e-06 0.01404 -2.4532681697627497e-06 0.014050000000000002 -1.0044566456550132e-05 0.014060000000000001 1.2449849907075846e-06 0.014070000000000001 1.5044903622935864e-06 0.014080000000000001 1.7415775746889865e-06 0.014090000000000002 4.0847295809851724e-06 0.014100000000000001 -3.1992859313086316e-06 0.014110000000000001 8.5739880755181796e-06 0.014120000000000001 3.2480280962698506e-06 0.014130000000000002 1.0572237868202778e-06 0.014140000000000002 -1.9264591785439714e-06 0.014150000000000001 4.7574888091555628e-06 0.014160000000000001 -3.8211480131584224e-06 0.01417 3.2968374060321943e-06 0.014180000000000002 -4.8747642360921392e-06 0.014190000000000001 -5.4132095870247379e-06 0.014200000000000001 -7.078251197207343e-06 0.01421 2.1383407575424071e-06 0.014220000000000002 -2.4323969402927068e-06 0.014230000000000001 -7.6128011409313353e-06 0.014240000000000001 -3.1943434306546911e-06 0.014250000000000001 1.1514073685369828e-06 0.014260000000000002 7.857966806415136e-06 0.014270000000000001 -4.0937210351350082e-06 0.014280000000000001 1.181154800900217e-05 0.014290000000000001 7.8980059658871901e-07 0.014300000000000002 -2.4299574593932664e-06 0.014310000000000002 1.0223370323686707e-06 0.014320000000000001 6.5373190653167227e-06 0.014330000000000001 -1.9238784733368003e-06 0.01434 -1.9197975527168485e-06 0.014350000000000002 -3.7868076139460484e-06 0.014360000000000001 -2.1049483774672933e-06 0.014370000000000001 9.0155810494928401e-06 0.01438 4.1526237777807501e-06 0.014390000000000002 6.4004999923999748e-06 0.014400000000000001 4.6794388322115201e-06 0.014410000000000001 -3.2540075667582222e-06 0.014420000000000001 2.1874908344247034e-06 0.014430000000000002 1.4777242025884339e-05 0.014440000000000001 3.3308920561364754e-06 0.014450000000000001 -3.8108990987405022e-06 0.014460000000000001 7.145330636092467e-06 0.014470000000000002 1.6822259200673296e-06 0.014480000000000002 1.4238510477371326e-06 0.014490000000000001 -3.4945177363542208e-06 0.014500000000000001 -3.9743440165815015e-06 0.01451 5.4381944358725703e-06 0.014520000000000002 1.5705069408690435e-06 0.014530000000000001 2.9016042932270071e-06 0.014540000000000001 -5.9777706407329257e-06 0.01455 -1.3483241488354695e-06 0.014560000000000002 -3.4554885639049072e-06 0.014570000000000001 -5.5513991023919359e-06 0.014580000000000001 -5.8073306598253665e-06 0.014590000000000001 -8.5133903256193599e-06 0.014600000000000002 -9.6602896765277336e-06 0.014610000000000001 -2.7770812675673846e-06 0.014620000000000001 -7.474529904679906e-06 0.014630000000000001 -3.673173394797013e-07 0.014640000000000002 7.2200632502008476e-06 0.014650000000000002 2.1574502442050307e-06 0.014660000000000001 2.5066568190609646e-06 0.014670000000000001 6.1692115487678761e-06 0.01468 -4.0568779687099955e-06 0.014690000000000002 -3.6828463876204999e-06 0.014700000000000001 1.3962654576659131e-05 0.014710000000000001 3.4424509719184415e-07 0.01472 -1.0033300796470861e-06 0.014730000000000002 8.8328065909255012e-07 0.014740000000000001 -9.3513211355565954e-06 0.014750000000000001 -2.0545964872403615e-06 0.014760000000000001 5.1610597145798811e-06 0.014770000000000002 -3.8248922362582872e-06 0.014780000000000001 -4.1896295801145195e-06 0.014790000000000001 -5.7078124814759339e-06 0.014800000000000001 5.5528487607500158e-06 0.014810000000000002 -4.3847263850895051e-06 0.014820000000000002 8.2965588752074774e-07 0.014830000000000001 6.7076309902793734e-06 0.014840000000000001 6.0636726593236842e-07 0.01485 1.4147722171834857e-06 0.014860000000000002 2.4359784450972691e-06 0.014870000000000001 -4.8277851690034113e-07 0.014880000000000001 -1.660676198090006e-06 0.01489 -6.6627846539998073e-06 0.014900000000000002 1.3744673687438545e-06 0.014910000000000001 3.9231464514778975e-06 0.014920000000000001 -9.7343120781246681e-06 0.014930000000000001 -6.2452083707236114e-06 0.014940000000000002 5.2940095080360334e-06 0.014950000000000001 4.0436662596693674e-06 0.014960000000000001 -5.0245705695552568e-06 0.014970000000000001 2.4132247395065415e-06 0.014980000000000002 2.7031286858995039e-06 0.014990000000000002 3.6086144907585395e-06 0.015000000000000001 7.2979404051274278e-07 0.015010000000000001 8.9796210274800988e-06 0.01502 7.9767892352448658e-06 0.015030000000000002 -7.6362955292218433e-06 0.015040000000000001 1.0371551089510752e-05 0.015050000000000001 -1.5324513184630199e-06 0.01506 -4.066100905408215e-06 0.015070000000000002 -8.5217061656892124e-06 0.015080000000000001 -2.0793070377106595e-06 0.015090000000000001 -3.0078366490026212e-06 0.015100000000000001 -9.3524335223937552e-07 0.015110000000000002 1.9912489376117751e-06 0.015120000000000001 -8.2094060403481581e-06 0.015130000000000001 -3.0336871701191158e-06 0.015140000000000001 6.5962986636387304e-06 0.015150000000000002 1.4262289886536273e-06 0.015160000000000002 -1.4026023833243545e-06 0.015170000000000001 -6.8694164104761221e-06 0.015180000000000001 -9.4051627005891906e-07 0.01519 1.1227433679790785e-06 0.015200000000000002 4.5650111063734888e-06 0.015210000000000001 -3.332482097007157e-06 0.015220000000000001 5.1458870738702672e-06 0.01523 6.010391924345592e-06 0.015240000000000002 -6.6665825443135454e-06 0.015250000000000001 4.8743872676829228e-06 0.015260000000000001 -2.4731963772689039e-06 0.015270000000000001 5.7653569930371204e-06 0.015280000000000002 -1.6368149688763708e-06 0.015290000000000002 -2.3335047432625825e-06 0.015300000000000001 6.7248646781107662e-06 0.015310000000000001 -6.4561395288620823e-06 0.015320000000000002 7.1803587314932707e-06 0.015330000000000002 -4.8092569136142756e-06 0.015340000000000001 -2.3634644243847563e-06 0.015350000000000001 -4.2933128606007561e-06 0.015360000000000002 -2.4710695874638156e-06 0.015370000000000002 -6.2556178684405629e-06 0.015380000000000001 8.4852725641426453e-06 0.015390000000000001 -6.2853298491261215e-07 0.0154 -4.5236463427127358e-06 0.015410000000000002 4.8218540018706921e-06 0.015420000000000001 -8.7111839937989634e-06 0.015430000000000001 -5.1044628743796552e-06 0.015440000000000001 8.2008020118970046e-06 0.015450000000000002 -6.1793825123229421e-06 0.015460000000000002 5.4995550497033521e-08 0.015470000000000001 4.2300534109179471e-06 0.015480000000000001 2.2021176036041433e-08 0.015490000000000002 -1.005766126132396e-06 0.015500000000000002 7.622749860609319e-06 0.015510000000000001 -1.090039743913961e-05 0.015520000000000001 3.1362060493268048e-06 0.015530000000000002 2.272147676563362e-06 0.015540000000000002 4.6762393274724956e-06 0.015550000000000001 -4.0864126739182429e-07 0.015560000000000001 -3.801910217032264e-06 0.015570000000000001 -4.1555262398742865e-06 0.015580000000000002 2.8914599737362357e-06 0.015590000000000001 9.4878414005599882e-06 0.015600000000000001 -1.3058301805746814e-06 0.015610000000000001 6.4791171743085624e-06 0.015620000000000002 -2.533010988230831e-08 0.015630000000000002 -4.5254517554141868e-07 0.015640000000000001 -6.1031127718181058e-06 0.015650000000000001 1.0512295313182171e-05 0.01566 4.5767879351050021e-07 0.01567 -1.9395106033476302e-06 0.015680000000000003 -1.1062914828816037e-06 0.015690000000000003 -9.1124352826753841e-07 0.015700000000000002 -4.3804863376474802e-06 0.015710000000000002 2.9455346533962024e-06 0.015720000000000001 -1.282000027161494e-06 0.015730000000000001 -9.7082227854170913e-07 0.015740000000000001 3.9347243505487065e-06 0.01575 -3.6371011903206741e-06 0.01576 -7.7679952963891886e-06 0.015770000000000003 -3.1403049736243856e-06 0.015780000000000002 1.3570553371319706e-05 0.015790000000000002 8.5135058833134007e-06 0.015800000000000002 -8.9719142738014889e-06 0.015810000000000001 -1.7906046303025933e-06 0.015820000000000001 -6.3394374440511706e-06 0.01583 -7.0084724158795887e-08 0.01584 6.6962786342212128e-06 0.015850000000000003 5.2744136542244218e-06 0.015860000000000003 3.7181340383997828e-07 0.015870000000000002 7.1087134173876166e-07 0.015880000000000002 3.6015624007791728e-06 0.015890000000000001 -9.6648528100769827e-06 0.015900000000000001 7.4564647231811191e-06 0.015910000000000001 -4.1690399623775312e-06 0.01592 7.6642792523852333e-06 0.01593 -5.6730823109007852e-06 0.015940000000000003 -3.7812375004890519e-07 0.015950000000000002 8.4099327482807638e-06 0.015960000000000002 7.2629430796618907e-06 0.015970000000000002 -1.8742516865393981e-06 0.015980000000000001 -3.5662059924616143e-06 0.015990000000000001 1.9992210884728779e-06 0.016 1.0853817053791994e-05 0.01601 -4.386246248638859e-06 0.016020000000000003 7.2641941677390917e-06 0.016030000000000003 -7.7256203114842494e-06 0.016040000000000002 -3.8071631534906411e-06 0.016050000000000002 3.9359632902639936e-06 0.016060000000000001 7.5690921465794076e-07 0.016070000000000001 -7.5852290696785879e-06 0.016080000000000001 2.7607816385475873e-06 0.01609 -9.5495783708090669e-07 0.0161 9.9695107747818677e-07 0.016110000000000003 -2.0383390947411117e-06 0.016120000000000002 4.4196646235688541e-06 0.016130000000000002 4.5591031533387937e-06 0.016140000000000002 2.3946288335504484e-06 0.016150000000000001 2.7032970128608584e-06 0.016160000000000001 4.7977816068061319e-06 0.01617 6.3482074432832551e-06 0.01618 -3.9894932722801695e-06 0.016190000000000003 -2.7938685823868785e-07 0.016200000000000003 -3.2736261198350956e-06 0.016210000000000002 -2.8683812941714094e-06 0.016220000000000002 4.3340120134887683e-06 0.016230000000000001 -8.2109913323282135e-06 0.016240000000000001 -5.0573289419317664e-06 0.016250000000000001 -5.1513043225979412e-07 0.01626 -3.3233523395552248e-06 0.01627 -8.5373477052813608e-06 0.016280000000000003 -3.9727838599059029e-06 0.016290000000000002 -3.165165318114094e-06 0.016300000000000002 -5.8693612108376976e-06 0.016310000000000002 -1.4480952620774647e-06 0.016320000000000001 -3.641581044908975e-06 0.016330000000000001 8.4715094923921964e-07 0.01634 7.4243232717136401e-07 0.01635 -4.0571891444173343e-06 0.016360000000000003 -5.2035817509609069e-06 0.016370000000000003 3.1098897064484529e-06 0.016380000000000002 9.6397818710559385e-07 0.016390000000000002 -2.8363509902903916e-06 0.016400000000000001 5.9457571068504879e-06 0.016410000000000001 3.9161492432856149e-06 0.016420000000000001 -7.4629300710104944e-07 0.01643 7.4695827318418954e-06 0.01644 -8.9790604871689963e-06 0.016450000000000003 5.1357262798282912e-07 0.016460000000000002 -3.7306076368118109e-07 0.016470000000000002 2.6541285967834209e-06 0.016480000000000002 -6.1699234162403111e-06 0.016490000000000001 5.851683355154836e-06 0.016500000000000001 7.726643568990624e-06 0.01651 4.1171431322744413e-06 0.01652 1.175685196171181e-05 0.016530000000000003 1.5342876728724653e-05 0.016540000000000003 -5.5988203594868393e-06 0.016550000000000002 -1.9881472115713296e-06 0.016560000000000002 5.5596867924898822e-06 0.016570000000000001 -3.1643756261070138e-06 0.016580000000000001 2.8164371611459441e-06 0.016590000000000001 -4.4783956995108353e-06 0.0166 -1.1007783917675786e-05 0.01661 8.1742531598558094e-08 0.016620000000000003 -1.0868233530979812e-05 0.016630000000000002 5.8471289761272688e-06 0.016640000000000002 -1.2054141560468443e-05 0.016650000000000002 4.2998347098970175e-06 0.016660000000000001 5.5239249427911851e-07 0.016670000000000001 -5.9147717565060346e-06 0.01668 3.7225822908428817e-06 0.01669 1.0843747023369376e-07 0.016700000000000003 2.9072063155041282e-06 0.016710000000000003 2.3626849430143169e-06 0.016720000000000002 -4.5703181572449837e-06 0.016730000000000002 -1.260928164171655e-06 0.016740000000000001 -5.6572065213863784e-06 0.016750000000000001 -3.910254642735843e-06 0.016760000000000001 -2.544960990035591e-06 0.01677 1.3425586840926181e-06 0.01678 5.4617284152139834e-07 0.016790000000000003 -2.7769874535715473e-06 0.016800000000000002 -5.0806191732818706e-06 0.016810000000000002 -6.7747440285877839e-06 0.016820000000000002 1.8293460966523476e-06 0.016830000000000001 2.1663667212003415e-06 0.016840000000000001 3.6479959429305923e-06 0.01685 1.2412386499218149e-06 0.01686 -8.2691449212756516e-06 0.016870000000000003 4.3822299235963887e-06 0.016880000000000003 1.0068916217451143e-05 0.016890000000000002 2.351365541667842e-07 0.016900000000000002 -2.7691077715569786e-06 0.016910000000000001 -6.217251492904103e-06 0.016920000000000001 -5.6823069020604227e-06 0.016930000000000001 4.0173488119415768e-06 0.01694 -7.2810904597230966e-06 0.01695 2.8735070825186727e-06 0.016960000000000003 -1.3209299760240301e-05 0.016970000000000002 -3.361031588337238e-06 0.016980000000000002 5.1243273073003285e-06 0.016990000000000002 3.5008826804895906e-06 0.017000000000000001 -4.3655066367392327e-06 0.017010000000000001 -2.5756776058315913e-06 0.01702 -5.49607543798275e-06 0.01703 6.6778662099957514e-06 0.017040000000000003 -2.7919862608663215e-07 0.017050000000000003 5.499410377584928e-06 0.017060000000000002 -2.4742818644335907e-06 0.017070000000000002 3.0174355291176386e-06 0.017080000000000001 2.6855437427587268e-06 0.017090000000000001 9.9567671678358709e-07 0.017100000000000001 -4.6382492741727326e-06 0.01711 8.8307914216724496e-06 0.01712 2.8508183414976109e-06 0.017130000000000003 -2.1051027528806451e-06 0.017140000000000002 -2.3407188571840933e-06 0.017150000000000002 -7.7137724713124954e-06 0.017160000000000002 4.9234011865246302e-06 0.017170000000000001 5.569550346432442e-07 0.017180000000000001 -8.3851907251642913e-06 0.01719 6.6059351122169735e-06 0.0172 -1.2347651432705755e-07 0.017210000000000003 8.6513292536817487e-06 0.017220000000000003 -2.2093155634310229e-06 0.017230000000000002 2.8788604257271278e-06 0.017240000000000002 4.6833315834315273e-06 0.017250000000000001 -9.7507985170479966e-07 0.017260000000000001 6.4421080096396795e-06 0.017270000000000001 -1.4080498554349692e-06 0.01728 -1.0161013765591916e-05 0.01729 9.5483181976996081e-06 0.017300000000000003 1.2843766068299601e-05 0.017310000000000002 -3.5599513081413497e-06 0.017320000000000002 -9.8772220474711884e-06 0.017330000000000002 -3.557414764065223e-06 0.017340000000000001 3.7260225479787556e-06 0.017350000000000001 -1.0790982888095168e-05 0.01736 -8.0826277789897301e-06 0.01737 4.091428088369218e-06 0.017380000000000003 -5.0934501662127674e-06 0.017390000000000003 4.9206799479651588e-06 0.017400000000000002 2.566101029116194e-06 0.017410000000000002 -3.5178804996731625e-07 0.017420000000000001 -3.3897852679646987e-06 0.017430000000000001 -3.2811331869139554e-06 0.017440000000000001 -1.8358567289746732e-07 0.01745 -5.856478028310292e-06 0.01746 -1.4661749255298088e-06 0.017470000000000003 5.5604931427707562e-06 0.017480000000000002 1.0258177565638854e-05 0.017490000000000002 6.0119351836804349e-07 0.017500000000000002 3.6431818966744581e-06 0.017510000000000001 2.5930639062583967e-06 0.017520000000000001 -1.8841954100108841e-06 0.01753 1.2657564512914485e-06 0.01754 -4.46234257029206e-06 0.017550000000000003 -3.9354634701189267e-07 0.017560000000000003 -6.6083795610797337e-06 0.017570000000000002 4.0894204197703687e-06 0.017580000000000002 -1.2797501921544979e-06 0.017590000000000001 1.2266138436714211e-05 0.017600000000000001 1.7727407761326567e-06 0.017610000000000001 3.5217263953114631e-06 0.01762 6.2565593505217957e-06 0.01763 1.5885738440293327e-06 0.017640000000000003 -1.7799135286624109e-06 0.017650000000000002 -7.9837329370662802e-06 0.017660000000000002 7.8984745719442351e-06 0.017670000000000002 -9.4433407277057503e-06 0.017680000000000001 3.920131603825694e-06 0.017690000000000001 -1.8919984055483461e-06 0.0177 -7.4963543619006771e-06 0.01771 -1.2328526609574438e-05 0.017720000000000003 8.3959933965027218e-07 0.017730000000000003 -1.3400600984750302e-06 0.017740000000000002 7.155017643574422e-07 0.017750000000000002 -4.8135161747308431e-06 0.017760000000000001 9.4374415231976463e-06 0.017770000000000001 2.2562274870189295e-06 0.017780000000000001 9.2567381229197133e-06 0.01779 -3.0681698339894843e-06 0.0178 6.3744117983466458e-06 0.017810000000000003 3.7474832397516748e-06 0.017820000000000003 -4.5625013024596414e-06 0.017830000000000002 3.6686553352570986e-06 0.017840000000000002 7.3036647461725564e-07 0.017850000000000001 -5.9579237824452385e-08 0.017860000000000001 1.8933599375956477e-06 0.01787 -1.4016682591542916e-05 0.01788 7.8225450331910842e-09 0.017890000000000003 -5.3914026637067166e-06 0.017900000000000003 -2.7450550444435989e-06 0.017910000000000002 3.3115046514780853e-06 0.017920000000000002 -4.5037766132875327e-06 0.017930000000000001 8.2151335489964805e-06 0.017940000000000001 8.9358830904511506e-06 0.017950000000000001 2.0661643718957715e-06 0.01796 1.2335944032875985e-06 0.01797 4.0630619760154196e-06 0.017980000000000003 2.1163489546156781e-06 0.017990000000000003 -1.6323667960574079e-06 0.018000000000000002 -1.372753284956427e-06 0.018010000000000002 6.9103511930174866e-07 0.018020000000000001 2.3730350028329122e-06 0.018030000000000001 1.8022098936161458e-06 0.01804 -1.7068847409651371e-06 0.01805 -4.0817467889232051e-06 0.018060000000000003 2.8218263860283794e-06 0.018070000000000003 -5.0061261132388595e-06 0.018080000000000002 8.1604029674255952e-06 0.018090000000000002 1.0238000644772252e-06 0.018100000000000002 3.7712407982839881e-06 0.018110000000000001 1.3911609277920392e-05 0.018120000000000001 -5.0436187808369442e-06 0.01813 4.8433682034563975e-06 0.01814 8.1564657000754307e-07 0.018150000000000003 3.3740889098228903e-06 0.018160000000000003 -8.4671900958924731e-06 0.018170000000000002 -6.2157223724670547e-06 0.018180000000000002 4.610695279645147e-06 0.018190000000000001 1.0969533796560073e-05 0.018200000000000001 6.2030900747246976e-07 0.01821 2.8152747084533084e-06 0.01822 -4.2424663292347795e-06 0.018230000000000003 -1.9713911206886334e-06 0.018240000000000003 5.1843099633717783e-06 0.018250000000000002 -2.7137653346753317e-06 0.018260000000000002 -4.1438996368990579e-06 0.018270000000000002 4.8271461612687525e-06 0.018280000000000001 7.9631452470558021e-06 0.018290000000000001 4.277837929109727e-06 0.0183 -3.3057282563501748e-06 0.01831 2.4518978922313939e-06 0.018320000000000003 3.5729176824092867e-07 0.018330000000000003 9.9271379327852793e-07 0.018340000000000002 6.9345845439635576e-06 0.018350000000000002 -2.0953390817858753e-06 0.018360000000000001 4.8116816546470194e-06 0.018370000000000001 -1.2338748472586352e-06 0.018380000000000001 -8.6869733796548235e-06 0.01839 -4.169570182229686e-06 0.018400000000000003 6.6011545578281956e-06 0.018410000000000003 -4.0447146655650266e-06 0.018420000000000002 -4.8018667675434097e-06 0.018430000000000002 -6.3792485324942422e-06 0.018440000000000002 -4.9586425004430362e-06 0.018450000000000001 2.6261971217953754e-06 0.018460000000000001 -5.5534237347083508e-06 0.01847 -7.6883303775856404e-06 0.01848 1.0246872944821537e-05 0.018490000000000003 1.3670992854183443e-06 0.018500000000000003 2.3809793878106139e-06 0.018510000000000002 1.1475118866655716e-05 0.018520000000000002 -6.2803309385879362e-07 0.018530000000000001 8.8323124694624998e-06 0.018540000000000001 -2.3900272106600155e-06 0.018550000000000001 -1.2419677552092359e-06 0.01856 -4.5908699656258792e-06 0.018570000000000003 -9.668828374425563e-08 0.018580000000000003 -2.0510812334481716e-06 0.018590000000000002 2.0643898195982514e-06 0.018600000000000002 5.1177652638909061e-06 0.018610000000000002 3.1522280207710237e-06 0.018620000000000001 -1.415276298513947e-06 0.018630000000000001 2.6605967136156314e-06 0.01864 7.8921951375145607e-06 0.01865 -2.8118586308486586e-06 0.018660000000000003 4.3549328131462715e-06 0.018670000000000003 -2.1275497858677031e-06 0.018680000000000002 -1.2150708991164984e-05 0.018690000000000002 8.3610036061062364e-06 0.018700000000000001 9.6779841583690987e-06 0.018710000000000001 3.4650556755837746e-06 0.018720000000000001 4.2239156332481991e-06 0.01873 -2.9589134270378639e-06 0.018740000000000003 -1.6293377450121247e-06 0.018750000000000003 -9.6229686699561623e-07 0.018760000000000002 -4.217093811088943e-06 0.018770000000000002 -4.5696682533342481e-06 0.018780000000000002 -4.1639040412793623e-06 0.018790000000000001 -2.7846184115781815e-07 0.018800000000000001 -2.3210764328453251e-06 0.01881 -2.269120064821126e-06 0.01882 1.0512276256581962e-05 0.018830000000000003 3.5958372641511852e-06 0.018840000000000003 4.9689042780505491e-07 0.018850000000000002 1.3888062464622819e-06 0.018860000000000002 1.3141479645015463e-05 0.018870000000000001 6.6462659873437766e-06 0.018880000000000001 3.2432972289988128e-06 0.018890000000000001 3.2520630665079045e-06 0.0189 7.1098132286598397e-06 0.018910000000000003 -6.6667717958402691e-06 0.018920000000000003 -8.157180765151934e-07 0.018930000000000002 1.4142306730640593e-06 0.018940000000000002 -2.445006814364952e-06 0.018950000000000002 1.1703364322426536e-06 0.018960000000000001 -1.3524031969971593e-06 0.018970000000000001 -4.5586989930564853e-07 0.01898 -3.7427089484923244e-06 0.01899 5.7416722167951375e-08 0.019000000000000003 4.904110621547631e-06 0.019010000000000003 1.3247386803197108e-06 0.019020000000000002 -4.7193792516872515e-06 0.019030000000000002 -8.1467951711811516e-06 0.019040000000000001 -2.7828033935378085e-06 0.019050000000000001 -2.4020110254633542e-06 0.019060000000000001 9.2825806180380217e-07 0.01907 3.6466075423630442e-06 0.019080000000000003 -3.7347864843366288e-08 0.019090000000000003 4.5492761422234929e-06 0.019100000000000002 1.7881483476743969e-06 0.019110000000000002 -4.1386275356510449e-06 0.019120000000000002 2.9789999048500131e-06 0.019130000000000001 4.0659715428388599e-06 0.019140000000000001 -4.4786551126788128e-06 0.01915 -3.4713294703023548e-06 0.01916 -4.3436015695814977e-06 0.019170000000000003 3.0714128208101996e-06 0.019180000000000003 1.2140215666102021e-06 0.019190000000000002 -4.8068547893199505e-06 0.019200000000000002 -6.5362265896704681e-06 0.019210000000000001 -3.8397324547795423e-06 0.019220000000000001 -2.8455898134824438e-06 0.019230000000000001 8.4077488683401225e-06 0.01924 -6.3332498740396243e-06 0.019250000000000003 7.8771379998514915e-06 0.019260000000000003 -1.8497536713730416e-06 0.019270000000000002 7.4602685938082222e-06 0.019280000000000002 -1.7842220145890087e-06 0.019290000000000002 3.4387481871213297e-07 0.019300000000000001 1.1482315003326864e-06 0.019310000000000001 2.9627317464204674e-06 0.01932 -4.2200226671024736e-06 0.01933 -1.4388423571660965e-06 0.019340000000000003 6.904900876499403e-06 0.019350000000000003 6.1182251089229482e-07 0.019360000000000002 4.4529065220053921e-06 0.019370000000000002 -1.6049997583026312e-05 0.019380000000000001 6.9216610357952627e-06 0.019390000000000001 1.5776587958353281e-06 0.019400000000000001 -3.4714795749340488e-07 0.01941 -7.1480115649449792e-07 0.019420000000000003 1.4232245247816064e-08 0.019430000000000003 3.7096865314434296e-06 0.019440000000000002 3.1641076016343148e-07 0.019450000000000002 5.3763045843955231e-06 0.019460000000000002 2.4837021939056382e-06 0.019470000000000001 3.6545576484810006e-06 0.019480000000000001 9.5064276127767834e-06 0.01949 5.3941266835128158e-07 0.0195 -1.743268000412254e-06 0.019510000000000003 -5.7778553839326153e-06 0.019520000000000003 -3.0544348911202482e-06 0.019530000000000002 8.9853035638941226e-06 0.019540000000000002 3.728910247087022e-06 0.019550000000000001 -6.3329408429979629e-06 0.019560000000000001 1.9948625347103638e-08 0.019570000000000001 1.4409252669088041e-06 0.01958 1.665334083381774e-07 0.019590000000000003 3.4138357952017791e-06 0.019600000000000003 -3.6664369895498116e-06 0.019610000000000002 -9.1117356097189902e-07 0.019620000000000002 2.2088451183259619e-06 0.019630000000000002 -3.6545105214031969e-06 0.019640000000000001 -1.8893592186624837e-06 0.019650000000000001 -3.8489124702068425e-07 0.01966 3.71395139448943e-06 0.01967 1.579635285454356e-06 0.019680000000000003 -5.2901124924050558e-06 0.019690000000000003 -7.6892192553768112e-06 0.019700000000000002 -7.2515047807635264e-06 0.019710000000000002 3.6442366198360035e-06 0.019720000000000001 -7.8113683896155624e-06 0.019730000000000001 4.197049913872204e-09 0.019740000000000001 5.027756396649295e-06 0.01975 -1.0954548874668763e-07 0.019760000000000003 -9.679489147574201e-07 0.019770000000000003 -5.1553805087898089e-06 0.019780000000000002 7.0323814853524583e-06 0.019790000000000002 -2.1955181083710551e-06 0.019800000000000002 -2.9272143523724489e-06 0.019810000000000001 -8.3550569619338156e-06 0.019820000000000001 -6.2153586909269663e-06 0.01983 -5.5849689083319854e-06 0.01984 -5.0607583651678552e-07 0.019850000000000003 1.0027109010265342e-05 0.019860000000000003 2.2541997813214286e-06 0.019870000000000002 -6.9919146872865516e-06 0.019880000000000002 5.364636580854472e-06 0.019890000000000001 -4.2407195715126496e-06 0.019900000000000001 -4.3765992895048545e-06 0.019910000000000001 5.2500421756660304e-06 0.01992 -4.1226561424723173e-06 0.019930000000000003 -4.7408208433186495e-06 0.019940000000000003 1.81332648445322e-06 0.019950000000000002 -7.5803468542900163e-09 0.019960000000000002 -2.4727317906348008e-06 0.019970000000000002 2.727706819397042e-06 0.019980000000000001 -1.0368673770949718e-06 0.019990000000000001 7.3406477019614413e-07 0.02 1.0847719402117299e-06 0.02001 2.0610188388755294e-06 0.020020000000000003 5.7139955997084262e-07 0.020030000000000003 8.7223400224655082e-06 0.020040000000000002 -5.6370778441731787e-06 0.020050000000000002 3.1618115764028417e-06 0.020060000000000001 -2.8452858532711618e-08 0.020070000000000001 4.7250618799198263e-06 0.020080000000000001 -1.6964401982398877e-06 0.02009 3.0247212461605037e-06 0.020100000000000003 1.3981422264699477e-06 0.020110000000000003 5.8208815037911872e-07 0.020120000000000002 -3.9698833009659071e-06 0.020130000000000002 6.0904489921545776e-06 0.020140000000000002 1.618817954367769e-06 0.020150000000000001 6.0010934355264852e-06 0.020160000000000001 -6.6457102438082055e-06 0.02017 2.7905964687982319e-06 0.02018 1.1224669030427124e-06 0.020190000000000003 1.3890143882170711e-06 0.020200000000000003 1.181764316578216e-06 0.020210000000000002 5.2014650182103852e-06 0.020220000000000002 5.8878037134619118e-07 0.020230000000000001 4.5257795169887938e-06 0.020240000000000001 -1.3167502069887198e-06 0.020250000000000001 6.601098429342089e-06 0.02026 6.3832415552329487e-06 0.020270000000000003 2.2828928252457356e-06 0.020280000000000003 -6.6294213782199404e-06 0.020290000000000002 -1.4193872842377621e-06 0.020300000000000002 -1.0118048658044255e-06 0.020310000000000002 -3.0644880712437008e-06 0.020320000000000001 -8.663469185212671e-06 0.020330000000000001 -2.3467994988784907e-06 0.02034 -3.2758162879699077e-06 0.02035 3.9868914398619482e-06 0.020360000000000003 8.2168045126073973e-06 0.020370000000000003 1.1809603945315692e-06 0.020380000000000002 1.6749166423684876e-06 0.020390000000000002 -2.0957406384791483e-06 0.020400000000000001 -6.1227205961567659e-06 0.020410000000000001 2.5466796437052477e-06 0.020420000000000001 -9.0655197447233783e-06 0.02043 2.7665771496755138e-06 0.020440000000000003 5.1461421468371175e-06 0.020450000000000003 -2.1567123165736999e-06 0.020460000000000002 2.6249664816543526e-06 0.020470000000000002 -4.5588259816027444e-07 0.020480000000000002 -5.1556232287252923e-08 0.020490000000000001 -2.3814548047678789e-06 0.020500000000000001 -7.3533590684879451e-06 0.02051 3.9266822784400077e-06 0.02052 2.6974375903053608e-07 0.020530000000000003 -4.8765691180030578e-06 0.020540000000000003 -2.2888033833838733e-06 0.020550000000000002 -1.1292909084354198e-06 0.020560000000000002 -3.703236605168181e-06 0.020570000000000001 -1.9756669121262713e-06 0.020580000000000001 -8.1241359753868705e-07 0.020590000000000001 -3.568032867241458e-07 0.0206 -3.9329507638839943e-07 0.020610000000000003 -4.1353188135498789e-06 0.020620000000000003 1.4807156553729159e-07 0.020630000000000003 -9.1150798888476193e-08 0.020640000000000002 -6.9693172779136443e-08 0.020650000000000002 -2.2076507162132566e-06 0.020660000000000001 5.9347458272184799e-06 0.020670000000000001 -3.2774158793340997e-06 0.02068 6.9735181515296092e-07 0.02069 5.9399821706304341e-06 0.020700000000000003 1.9117098992447187e-06 0.020710000000000003 -1.0255990977402794e-05 0.020720000000000002 -8.4632012665900981e-06 0.020730000000000002 9.177604421363471e-06 0.020740000000000001 -8.5240119109040461e-06 0.020750000000000001 -7.3596863035514447e-06 0.020760000000000001 9.1587872203445934e-06 0.02077 9.8806466360828196e-06 0.020780000000000003 -5.7173119714798677e-06 0.020790000000000003 1.2138875544427571e-06 0.020800000000000003 -1.2867506734221127e-06 0.020810000000000002 5.9412243869588922e-06 0.020820000000000002 -3.5778758112722035e-06 0.020830000000000001 -8.1300650872282751e-07 0.020840000000000001 2.6211727965978011e-06 0.02085 -4.6736583371391622e-06 0.02086 -5.9219325641385271e-06 0.020870000000000003 3.6921282594402995e-06 0.020880000000000003 -3.7995329301828355e-06 0.020890000000000002 2.5963219514705108e-06 0.020900000000000002 1.5100821338829203e-06 0.020910000000000002 2.9244392816777246e-06 0.020920000000000001 1.581185528521158e-06 0.020930000000000001 -2.2780526436382153e-07 0.02094 -2.7303849755618174e-06 0.020950000000000003 -3.2704878126839686e-06 0.020960000000000003 2.5195313053391746e-06 0.020970000000000003 -4.2872843879819126e-06 0.020980000000000002 -3.3419333501292663e-06 0.020990000000000002 -8.8870410240618026e-07 0.021000000000000001 -4.2049023845695411e-06 0.021010000000000001 -2.0909753228156792e-06 0.02102 5.2529023068997784e-06 0.02103 2.8617336748931819e-06 0.021040000000000003 6.21824064847221e-06 0.021050000000000003 3.7812627132950562e-06 0.021060000000000002 2.618796035368461e-06 0.021070000000000002 2.8759081036484009e-07 0.021080000000000002 1.3202186691920083e-06 0.021090000000000001 2.7696526611370559e-06 0.021100000000000001 1.8646577125079693e-06 0.02111 -2.876587214348882e-06 0.021120000000000003 1.9175066295794092e-06 0.021130000000000003 -7.0919425184576537e-06 0.021140000000000003 -4.3207916773037066e-06 0.021150000000000002 -2.7340996949475852e-06 0.021160000000000002 1.1899689228303481e-05 0.021170000000000001 -2.5787007306733906e-06 0.021180000000000001 3.6517149367716302e-06 0.021190000000000001 2.8100032791978245e-06 0.0212 3.7252640004402547e-06 0.021210000000000003 -1.1811921502058065e-06 0.021220000000000003 1.1843027230774556e-05 0.021230000000000002 5.048713575461668e-06 0.021240000000000002 -1.8300424308758105e-06 0.021250000000000002 -7.0159994320522495e-07 0.021260000000000001 6.5525854227298269e-06 0.021270000000000001 -6.2899156193778535e-07 0.02128 5.4682926764455181e-06 0.021290000000000003 2.7354692921730275e-06 0.021300000000000003 7.0595602368761756e-07 0.021310000000000003 6.8596430650108744e-06 0.021320000000000002 -6.2040691942952336e-06 0.021330000000000002 -3.3764952063483952e-06 0.021340000000000001 2.5906043048872104e-06 0.021350000000000001 9.1028330697480443e-06 0.021360000000000001 -5.0595326159938016e-06 0.02137 3.2768484969581911e-06 0.021380000000000003 -2.7065223844603714e-06 0.021390000000000003 4.7790710931883875e-06 0.021400000000000002 -2.7540385028247686e-06 0.021410000000000002 -7.5587012231858219e-07 0.021420000000000002 -1.5799709137414748e-06 0.021430000000000001 5.2115274677059975e-06 0.021440000000000001 -3.628788536997606e-06 0.02145 -2.3248887471457256e-06 0.021460000000000003 1.4169065578480673e-06 0.021470000000000003 5.1412052940202686e-06 0.021480000000000003 3.5780666166062191e-06 0.021490000000000002 -2.3589094423859897e-06 0.021500000000000002 -1.1163390659375091e-06 0.021510000000000001 -8.1805465344687145e-06 0.021520000000000001 1.2835812493747951e-05 0.021530000000000001 7.7206351349369726e-07 0.02154 2.3000800956665049e-06 0.021550000000000003 -6.4475910856934062e-06 0.021560000000000003 1.7369048784500684e-06 0.021570000000000002 1.7257644785626399e-06 0.021580000000000002 2.12675791591347e-06 0.021590000000000002 -4.8961981354440589e-07 0.021600000000000001 4.8882257505319296e-06 0.021610000000000001 -1.7624271142626297e-06 0.02162 -7.7973822958634145e-06 0.021630000000000003 -3.8245872034959539e-06 0.021640000000000003 2.0807489987482256e-06 0.021650000000000003 9.7894495213207225e-06 0.021660000000000002 6.0215534490479455e-06 0.021670000000000002 -6.2372896800449675e-06 0.021680000000000001 2.4575057182056189e-06 0.021690000000000001 7.1414358303917643e-06 0.021700000000000001 -1.2357419907578285e-05 0.02171 1.0570389312277766e-06 0.021720000000000003 6.7822174714772467e-06 0.021730000000000003 -4.7092362986951404e-06 0.021740000000000002 -4.1587819969578192e-06 0.021750000000000002 3.7464316089791308e-06 0.021760000000000002 4.4242291504487928e-06 0.021770000000000001 -3.0450072660867302e-06 0.021780000000000001 -2.4947804127885046e-06 0.02179 5.7128989535962933e-06 0.021800000000000003 -2.1414439409648188e-07 0.021810000000000003 -9.5176647443478311e-06 0.021820000000000003 -2.405994856449901e-06 0.021830000000000002 -1.5441364966551209e-06 0.021840000000000002 1.0607688668770576e-05 0.021850000000000001 -5.8783300950885172e-06 0.021860000000000001 -3.261117776446112e-06 0.021870000000000001 5.8844420038143298e-06 0.02188 5.7154354538032796e-06 0.021890000000000003 8.9165994886561559e-06 0.021900000000000003 -9.894716668105787e-07 0.021910000000000002 4.018845419805996e-06 0.021920000000000002 1.8358817257669961e-06 0.021930000000000002 -9.1979811203019535e-07 0.021940000000000001 -9.1085254206924736e-06 0.021950000000000001 5.7037985788905434e-06 0.02196 5.935563318265182e-06 0.021970000000000003 9.7815849214674062e-07 0.021980000000000003 -1.1487698654551306e-07 0.021990000000000003 -5.8330069091792748e-06 0.022000000000000002 1.1141550570166864e-05 0.022010000000000002 -7.8264578565821318e-06 0.022020000000000001 -1.2377922317644459e-06 0.022030000000000001 -1.9682981436297665e-06 0.022040000000000001 1.1578418950898397e-06 0.02205 -3.4809779468367822e-06 0.022060000000000003 4.0551708906356616e-06 0.022070000000000003 -1.9352470810806e-06 0.022080000000000002 -6.1875813357016374e-09 0.022090000000000002 2.9566459561560378e-07 0.022100000000000002 -8.0394282318156462e-06 0.022110000000000001 -6.1745811168337454e-07 0.022120000000000001 -8.2613225093093172e-06 0.02213 1.9299053694577589e-06 0.022140000000000003 -2.9568592977847958e-07 0.022150000000000003 -9.1957855880893689e-07 0.022160000000000003 -1.833810868302047e-06 0.022170000000000002 9.9258225360297295e-06 0.022180000000000002 -7.3961848182737968e-06 0.022190000000000001 -3.5458130555233101e-06 0.022200000000000001 1.1093877512204206e-05 0.022210000000000001 -1.2057476726200252e-06 0.02222 -7.056368421636277e-07 0.022230000000000003 -3.1639295810534985e-06 0.022240000000000003 -3.493221925503388e-06 0.022250000000000002 1.2405646550031468e-06 0.022260000000000002 -3.8374281371904712e-06 0.022270000000000002 -8.8115528468194789e-06 0.022280000000000001 4.7058175824385339e-06 0.022290000000000001 2.4783082109915092e-06 0.0223 -1.2752373895082637e-05 0.022310000000000003 -2.7532792221390843e-06 0.022320000000000003 -1.3559800799836323e-06 0.022330000000000003 1.6615763688598915e-06 0.022340000000000002 1.0992406202235879e-05 0.022350000000000002 4.9298635003901563e-06 0.022360000000000001 -2.1951422705319674e-06 0.022370000000000001 -6.7315496186719631e-06 0.022380000000000001 -8.8210734286251415e-06 0.02239 -4.9238384958272774e-06 0.022400000000000003 1.6624680000766191e-06 0.022410000000000003 1.0593428980786097e-06 0.022420000000000002 6.7638474626710965e-07 0.022430000000000002 1.6480167259561419e-06 0.022440000000000002 4.8758863625310478e-06 0.022450000000000001 -1.8931224714114035e-06 0.022460000000000001 -5.9615799682738576e-06 0.02247 5.3430576052119395e-06 0.022480000000000003 -3.0039057832497952e-06 0.022490000000000003 2.0021820364016786e-07 0.022500000000000003 -5.98975178645944e-07 0.022510000000000002 -2.195949308557524e-07 0.022520000000000002 6.4374851287574139e-08 0.022530000000000001 7.251734369645351e-06 0.022540000000000001 5.213693275626718e-06 0.022550000000000001 -3.8509575056601581e-07 0.02256 -6.9978084485281787e-06 0.022570000000000003 -2.628941919500685e-06 0.022580000000000003 -7.310698277508067e-06 0.022590000000000002 -4.1087167519170432e-06 0.022600000000000002 3.4839931768023467e-07 0.022610000000000002 -1.0185939406850276e-05 0.022620000000000001 2.5740663875409675e-06 0.022630000000000001 1.2611279802452672e-06 0.02264 3.0399421476814167e-07 0.022650000000000003 7.6803961413671757e-06 0.022660000000000003 8.1335421677495082e-07 0.022670000000000003 1.4629550584018259e-06 0.022680000000000002 5.1548876374847149e-06 0.022690000000000002 -2.4780791858061516e-06 0.022700000000000001 6.1534133695395082e-06 0.022710000000000001 6.3285985333643986e-07 0.022720000000000001 -1.8654491038939208e-06 0.02273 -2.3971534871118288e-07 0.022740000000000003 -2.425812334184024e-06 0.022750000000000003 -4.8445158758814217e-06 0.022760000000000002 -3.4357235074476665e-06 0.022770000000000002 -3.6542834868155618e-06 0.022780000000000002 -2.2612018179786561e-06 0.022790000000000001 -5.6602504912387124e-07 0.022800000000000001 -4.7454717207346669e-06 0.02281 -2.7455163437459259e-06 0.022820000000000003 -2.6976343057729028e-06 0.022830000000000003 1.3186306220013209e-05 0.022840000000000003 -5.3171475003369135e-06 0.022850000000000002 -4.9527516683325941e-06 0.022860000000000002 -2.6496749693419273e-06 0.022870000000000001 1.7662846150414884e-06 0.022880000000000001 3.456866746656737e-06 0.022890000000000001 -2.9916488801408715e-06 0.0229 -1.2206260525154406e-05 0.022910000000000003 3.1170836204344931e-07 0.022920000000000003 4.8840712831633949e-06 0.022930000000000002 -1.8249267716882286e-06 0.022940000000000002 4.456540732615507e-06 0.022950000000000002 1.4016005700875456e-07 0.022960000000000001 -2.5225809783193293e-06 0.022970000000000001 -2.7837311176728229e-07 0.02298 1.1946165719793215e-06 0.022990000000000003 -7.9443908555263896e-06 0.023000000000000003 3.393243175956008e-06 0.023010000000000003 -8.7492381307564217e-06 0.023020000000000002 7.1850473064772007e-06 0.023030000000000002 2.2270761394388857e-06 0.023040000000000001 5.5991528090081391e-07 0.023050000000000001 -2.2825369713755935e-07 0.023060000000000001 -2.5617307093578527e-06 0.02307 -2.928172645729455e-06 0.023080000000000003 -4.6749662343352059e-06 0.023090000000000003 8.0656356682038568e-06 0.023100000000000002 -2.6779406119569192e-06 0.023110000000000002 2.6772608419958146e-06 0.023120000000000002 2.349742891583366e-06 0.023130000000000001 5.3118800127904205e-06 0.023140000000000001 -7.7463781822518673e-08 0.02315 -6.7364787926998507e-06 0.023160000000000004 1.8813543122646567e-06 0.023170000000000003 1.0387591484545014e-05 0.023180000000000003 7.0944838356719221e-07 0.023190000000000002 6.7166798621513186e-06 0.023200000000000002 -1.2016769760925203e-06 0.023210000000000001 1.5466287940293036e-05 0.023220000000000001 3.4760052325469429e-06 0.023230000000000001 -2.373554907879775e-06 0.02324 1.6239206077689144e-10 0.023250000000000003 -6.2872625540262362e-06 0.023260000000000003 1.2249434422001328e-05 0.023270000000000002 -3.5276033917562497e-06 0.023280000000000002 -1.2837424464618137e-06 0.023290000000000002 -3.4727346238121374e-06 0.023300000000000001 5.1149980106392883e-06 0.023310000000000001 -3.4395065226234209e-06 0.02332 4.6009615300723795e-06 0.023330000000000004 -5.8699424218329738e-06 0.023340000000000003 7.7869307578919365e-07 0.023350000000000003 5.0270722626462108e-06 0.023360000000000002 7.8787888841411934e-06 0.023370000000000002 9.6349927751454845e-06 0.023380000000000001 3.6892134742897947e-06 0.023390000000000001 -5.5275002144878395e-06 0.023400000000000001 4.1243544926531305e-06 0.02341 -5.5473820562820837e-06 0.023420000000000003 -6.5603100581702506e-06 0.023430000000000003 6.1612462363453641e-06 0.023440000000000003 5.1227641118731396e-06 0.023450000000000002 5.4034133656005928e-06 0.023460000000000002 -5.5975668286521501e-06 0.023470000000000001 -1.0437422892416969e-05 0.023480000000000001 -2.5184504899566432e-06 0.02349 4.588051611407018e-06 0.023500000000000004 -4.7705618709073473e-06 0.023510000000000003 -6.0856418659376752e-06 0.023520000000000003 -4.4920719065849009e-06 0.023530000000000002 1.572583880575608e-06 0.023540000000000002 -3.6234434407572457e-06 0.023550000000000001 -6.2693270664620319e-06 0.023560000000000001 -5.303873495233357e-06 0.023570000000000001 -1.0546323157236549e-05 0.02358 3.7320522676918082e-06 0.023590000000000003 7.8963303930673177e-06 0.023600000000000003 -4.8923691597024097e-07 0.023610000000000003 2.6051987439811761e-06 0.023620000000000002 -1.3856336236343294e-05 0.023630000000000002 3.1875920752079668e-06 0.023640000000000001 1.2157550074234352e-05 0.023650000000000001 -2.2109118147228416e-06 0.02366 -2.5707862697779257e-06 0.023670000000000004 -3.5705099909574173e-07 0.023680000000000003 -3.8954253125975558e-06 0.023690000000000003 -6.8117270637244494e-06 0.023700000000000002 9.3362586740658404e-06 0.023710000000000002 -9.3367685016582641e-06 0.023720000000000001 5.471984078231703e-07 0.023730000000000001 1.4746881786596861e-06 0.023740000000000001 -4.8055798073940672e-06 0.02375 -1.5547399541043737e-06 0.023760000000000003 -3.584035468841594e-06 0.023770000000000003 -9.5810491748275598e-07 0.023780000000000003 -3.440052269557403e-06 0.023790000000000002 -6.8369895061533364e-06 0.023800000000000002 2.9119030379328737e-06 0.023810000000000001 3.8134823009629203e-06 0.023820000000000001 -7.057496005262728e-06 0.02383 1.7363597970300489e-06 0.023840000000000004 5.2125156983306271e-06 0.023850000000000003 -3.5831268526613473e-06 0.023860000000000003 3.6708979418735069e-06 0.023870000000000002 -2.3952276431677023e-06 0.023880000000000002 5.3681899402018226e-06 0.023890000000000002 5.4952602635926377e-06 0.023900000000000001 8.5270552708841662e-07 0.023910000000000001 -1.7127047725247082e-06 0.02392 1.0984823003512647e-06 0.023930000000000003 -4.627451457847009e-06 0.023940000000000003 1.3985479669690514e-06 0.023950000000000003 -2.9692994311921107e-06 0.023960000000000002 -1.8865182061293947e-06 0.023970000000000002 -6.4198755962839112e-07 0.023980000000000001 1.694661317706762e-06 0.023990000000000001 3.7500563354472931e-06 0.024 -8.7743074903159762e-06)
.control
set numdgt=16
set wr_singlescale
set wr_vecnames
tran 1u 0.024 uic
wrdata wave.txt v(state) v(q) v(residual) v(candidate) v(denominator) v(target) v(stagepeak) v(delta) v(corr_first) v(corpeak) v(innerden)
quit
.endc
.end
