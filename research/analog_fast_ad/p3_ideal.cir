Fast AD centered state behavioral P5
.options reltol=1e-7 abstol=1e-12 vntol=1e-9
.model SW SW(Ron=1 Roff=1e12 Vt=0.5 Vh=0.1)
Vreset reset 0 PULSE(1 0 10u 10n 10n 10m 20m)
Vsample sample 0 PULSE(0 1 350u 10n 10n 10u 500u)
Vupdate update 0 PULSE(0 1 380u 10n 10n 10u 500u)
Sreset state 0 reset 0 SW
Cstate state 0 10n IC=0
Rleak state 0 1e12
Ileak state 0 0.0
Cnext stored 0 10n IC=0
Rnext stored 0 1e12
Ssample candidate stored sample 0 SW
Supdate stored_read state update 0 SW
Bstored stored_read 0 V=v(stored)
Bq q_drive 0 V=min(2,max(-2,(v(state)+0.0)))
Rq q_drive q 10
Cq q 0 100n
Rport_q q 0 1000000000000.0
Cport_q q 0 2p
Bd0 d0_drive 0 V=min(2,max(-2,(v(q)+0.16666666666666666*((1+0.0)*v(q)*v(q)+0.0)+0.0)))
Rd0 d0_drive d0 10
Cd0 d0 0 100n
Rport_d0 d0 0 1000000000000.0
Cport_d0 d0 0 2p
Bd1 d1_drive 0 V=min(2,max(-2,(v(d0)+0.33333333333333331*(v(q)-v(d0))+0.22222222222222221*((1+0.0)*v(d0)*v(q)+0.0)+0.0)))
Rd1 d1_drive d1 10
Cd1 d1 0 100n
Rport_d1 d1 0 1000000000000.0
Cport_d1 d1 0 2p
Bpeak stagepeak 0 V=max(max(abs(v(q_drive)),abs(v(d0_drive))),abs(v(d1_drive)))
Bres residual 0 V=2*(1+v(d1))
Bden denominator 0 V=1+v(residual)+(v(residual)-1)/3
Btarget target 0 V=v(q)+2*(1+v(q)/3)*(1-v(residual))/max(0.25,v(denominator))
Bcandidate candidate_drive 0 V=min(2,max(-2,v(target)))
Rcandidate candidate_drive candidate 10
Ccandidate candidate 0 100n
.control
set numdgt=16
set wr_singlescale
set wr_vecnames
tran 0.2u 3m uic
wrdata wave.txt v(state) v(q) v(residual) v(candidate) v(denominator) v(target) v(stagepeak)
quit
.endc
.end
